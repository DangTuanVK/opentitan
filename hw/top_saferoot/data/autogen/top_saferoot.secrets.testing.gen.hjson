// Copyright lowRISC contributors (OpenTitan project).
// Licensed under the Apache License, Version 2.0, see LICENSE for details.
// SPDX-License-Identifier: Apache-2.0
//
// ------------------- W A R N I N G: A U T O - G E N E R A T E D   C O D E !! -------------------//
// PLEASE DO NOT HAND-EDIT THIS FILE. IT HAS BEEN AUTO-GENERATED WITH THE FOLLOWING COMMAND:
// util/topgen.py -t hw/top_saferoot/data/top_saferoot.hjson
//                -o hw/top_saferoot/
{
  seed:
  {
    topgen_seed:
    {
      seed_mode: testing
      value: 8835721049284756123094857612309485761230948576123094857612309485
    }
    otp_img_seed:
    {
      seed_mode: testing
      value: 5240896041623584478075329919450214815678607265081667609216591226
    }
    lc_ctrl_seed:
    {
      seed_mode: testing
      value: 4018220101926439768841177094962692254966325604700177839491899000
    }
  }
  module:
  [
    {
      name: aes
      type: aes
      base_addrs:
      {
        null:
        {
          hart: 0x40000000
        }
      }
      memory: {}
      param_list:
      [
        {
          name: RndCnstClearingLfsrSeed
          desc: Default seed of the PRNG used for register clearing.
          type: aes_pkg::clearing_lfsr_seed_t
          randcount: 64
          randtype: data
          name_top: RndCnstAesClearingLfsrSeed
          default: 0x3f0332d5302206d5
          randwidth: 64
        }
        {
          name: RndCnstClearingLfsrPerm
          desc: Permutation applied to the LFSR of the PRNG used for clearing.
          type: aes_pkg::clearing_lfsr_perm_t
          randcount: 64
          randtype: perm
          name_top: RndCnstAesClearingLfsrPerm
          default: 0x35f2a2806166af3079be311656d65eea9b2140f754fd2468bbd03497c39aa82c8c9fed7b0f87312db2474f7936230617
          randwidth: 384
        }
        {
          name: RndCnstClearingSharePerm
          desc: Permutation applied to the clearing PRNG output for clearing the second share of registers.
          type: aes_pkg::clearing_lfsr_perm_t
          randcount: 64
          randtype: perm
          name_top: RndCnstAesClearingSharePerm
          default: 0x22049c599b858a433a9a51eae4bf1d0588706ab43d3ffe33c754f66cd1be0c49cebed0b25e902853b45fd1e8f754ab09
          randwidth: 384
        }
        {
          name: RndCnstMaskingLfsrSeed
          desc: Default seed of the PRNG used for masking.
          type: aes_pkg::masking_lfsr_seed_t
          randcount: 288
          randtype: data
          name_top: RndCnstAesMaskingLfsrSeed
          default: 0x390e822592151f469b081f1763a14688d45789d84f8ae104458e83e8ba2972a85388bc03
          randwidth: 288
        }
        {
          name: RndCnstMaskingLfsrPerm
          desc: Permutation applied to the output of the PRNG used for masking.
          type: aes_pkg::masking_lfsr_perm_t
          randcount: 160
          randtype: perm
          name_top: RndCnstAesMaskingLfsrPerm
          default: 0x3d820f89517490939d25753b49577a4e420027027273238a198746569115076b01202b60034b7021083e62766f1d8077223a5f869c375496995992304d7e0e10409f64632e84811e530c7117839a06367b7c948e0b2c97325b9e7d5e698c79044835789512056c8d612838269b14662f1355985a0d398b856e4f116a1a681b34447f2409523f4a4758883c8f1c414550672d2a1f43654c3116295c0a5d336d18
          randwidth: 1280
        }
      ]
    }
    {
      name: kmac
      type: kmac
      base_addrs:
      {
        null:
        {
          hart: 0x40020000
        }
      }
      memory: {}
      param_list:
      [
        {
          name: RndCnstLfsrSeed
          desc: Compile-time random data for PRNG default seed
          type: kmac_pkg::lfsr_seed_t
          randcount: 288
          randtype: data
          name_top: RndCnstKmacLfsrSeed
          default: 0x8c6955ef9b74ae5aecdfd36dd956b97d74a05d6b0697eda69759e0f328375d780bcb0728
          randwidth: 288
        }
        {
          name: RndCnstLfsrPerm
          desc: Compile-time random permutation for PRNG output
          type: kmac_pkg::lfsr_perm_t
          randcount: 800
          randtype: perm
          name_top: RndCnstKmacLfsrPerm
          default: 0xb043b5254e87cba3802b7395fc7e5c8a8e40a2ec401c6b78649897732997239ef7eee96b8ef1cd6891253498aa312d8545bf44a1d8c217a9aac4f47064d713044d42cad0e8a6b45bc74d1f1a081af48f1d16d2a2e26121c20c79909303243d16cd7725de95c9db5005c5a10344653d4bd8bf06389360819d2d8097dc3ead071155acc3c271e9cd9cd1518672042e4beae5b14ab5d9c43da13576b622208852958e5e71edd7b3e56ab9eb2ce0e01c576b58ac0c52bca6b604b17a1f05fe0b5006ab2c0807d8fb0a23528584d07c386f10cd852fa04c34fb72ab746c93902be1b94dbe487569c07d4157887f1de5b89cc3b205a8d1fe73e24474f08196a13a9a6f5c8638b2231ea9458c9e1a21185cb9c8ac52b5c641ba4c21bad981da0a14c307760251aa780d53a6c78ac23341c69394c836a6961a22882919b84c3ad428b54c06894bbc6fbaacd4e4f1571f3c390948d89815b9bc2fb6c0503dd384948d3ce46aad052dc85b58e6ba1df359c7072f375309c6aaf3e5aaa80346662668e00225b31ae8fb6e36c426156510956d20381408831a940a40c42595177f4f4c4ce75e838ae6f6c6ed325a4d9c47ea30863a23a2608066856b1a31c782f34c9e444b9469b18ef0c6a24aa59ee905f48f157471722820f930ee57848ae8ea17ccd366f46d188049dba0e8443d3e9b52aaca7f755b7b5d7c40a597b49c980ac0b8bc28f1d3f57d9d3074bd209b3120aa353314772eaa34268058d849e7e554b5a6024769951519f0fda7c154f19844a1e7c2be1e37df132eff374419dece18f1131a098f9605a46266e75178a9941fcbb8016a497a05788a0dca90c09513555891915325616b59eca061be4fd744f25f760fcaf059a41753791e00cd59f5c192d6481efea245113c1e56d3160d2bb9a3f679ba58638a2c82aa6cc2ec137b06d428954de9e10db82925ea29c57a56e9c049691b686802c62b30011928a797312c0de997e8f878e82aa0e340484c5c9951232c21c3338d44529dafc0bb0d3b31ea3a1af70b216589f919da0a3472c2c9a9390ca3b01549080c9c25999160ac01f5481b1f252e3d9917e45a0c4362546122804069db15bf0db91d803e8bfc087503e97bf6d09bda5794e92d280848231298bb6ae1b7492b80b094839506c7ae1d99a8ae748199948bbe14599e7a0d9a66530433df663533999e0a20358b96ca89735529f096943b67b792ad8849ba853a7456f835b5295245ecf2485e19269c542920f1706c9046ae37759e6bd6e38462b43b1c976ed64adf2e19c6bebb2401729c2d1010650c0ca170a6599086528b70c27e0ec12e29862d5968470352d854c558d29962c90461b6841d348a161c298b2436eddc7fe6344f00010605e4ff93c9f4b85d920feb104509ab1b65d0
          randwidth: 8000
        }
        {
          name: RndCnstBufferLfsrSeed
          desc: Compile-time random data for PRNG buffer default seed
          type: kmac_pkg::buffer_lfsr_seed_t
          randcount: 800
          randtype: data
          name_top: RndCnstKmacBufferLfsrSeed
          default: 0xbbc62eb593f433491d5a6b56add49c4bce1410ae81f226f8633e00bce711f69de8b57f77d04a4c7f0c472a0601acd6b15c90b1b2dda51373a6fbed4b64e9fbbf8648e57e1e21d470dee98e4d802baec167c734477d5a48bd1b827b470d24f33726b649c8
          randwidth: 800
        }
        {
          name: RndCnstMsgPerm
          desc: Compile-time random permutation for LFSR Message output
          type: kmac_pkg::msg_perm_t
          randcount: 64
          randtype: perm
          name_top: RndCnstKmacMsgPerm
          default: 0xe7f2078d1c4ed6a0c1c096ad2e6d2b64530f5787bd92c7eff96cd4829b809fa9537181366cdf02890c8a5fb4a81a1ddd
          randwidth: 384
        }
      ]
    }
    {
      name: csrng
      type: csrng
      base_addrs:
      {
        null:
        {
          hart: 0x40030000
        }
      }
      memory: {}
      param_list:
      [
        {
          name: RndCnstCsKeymgrDivNonProduction
          desc: Compile-time random bits for csrng state group diversification value
          type: csrng_pkg::cs_keymgr_div_t
          randcount: 384
          randtype: data
          name_top: RndCnstCsrngCsKeymgrDivNonProduction
          default: 0xc9995b4c75d4a87c72c59ab27f0c0edacb4082b75463eb186feef3306f2efdbd173cf5b6e5c4a435b33da6e315dc4a70
          randwidth: 384
        }
        {
          name: RndCnstCsKeymgrDivProduction
          desc: Compile-time random bits for csrng state group diversification value
          type: csrng_pkg::cs_keymgr_div_t
          randcount: 384
          randtype: data
          name_top: RndCnstCsrngCsKeymgrDivProduction
          default: 0x81eb1014ed62aeac40d270a9325a10c6c0ceb311aada0cda76ea4082c28892524b54bdf9a58708d7ad318d665b4273a9
          randwidth: 384
        }
      ]
    }
    {
      name: otbn
      type: otbn
      base_addrs:
      {
        null:
        {
          hart: 0x40080000
        }
      }
      memory: {}
      param_list:
      [
        {
          name: RndCnstUrndPrngSeed
          desc: Default seed of the PRNG used for URND.
          type: otbn_pkg::urnd_prng_seed_t
          randcount: 256
          randtype: data
          name_top: RndCnstOtbnUrndPrngSeed
          default: 0x243c826410ca42780ce8dab9ab70b1df1603c110ff8b3484070cca41a439ee44
          randwidth: 256
        }
        {
          name: RndCnstOtbnKey
          desc: Compile-time random reset value for IMem/DMem scrambling key.
          type: otp_ctrl_pkg::otbn_key_t
          randcount: 128
          randtype: data
          name_top: RndCnstOtbnOtbnKey
          default: 0x2b177ffa2a8f7269ec915f6a5805b99a
          randwidth: 128
        }
        {
          name: RndCnstOtbnNonce
          desc: Compile-time random reset value for IMem/DMem scrambling nonce.
          type: otp_ctrl_pkg::otbn_nonce_t
          randcount: 64
          randtype: data
          name_top: RndCnstOtbnOtbnNonce
          default: 0x8d66683630b6fcf8
          randwidth: 64
        }
      ]
    }
    {
      name: keymgr
      type: keymgr
      base_addrs:
      {
        null:
        {
          hart: 0x40100000
        }
      }
      memory: {}
      param_list:
      [
        {
          name: RndCnstLfsrSeed
          desc: Compile-time random bits for initial LFSR seed
          type: keymgr_pkg::lfsr_seed_t
          randcount: 64
          randtype: data
          name_top: RndCnstKeymgrLfsrSeed
          default: 0x3e687338cbadfe0a
          randwidth: 64
        }
        {
          name: RndCnstLfsrPerm
          desc: Compile-time random permutation for LFSR output
          type: keymgr_pkg::lfsr_perm_t
          randcount: 64
          randtype: perm
          name_top: RndCnstKeymgrLfsrPerm
          default: 0x77a57ed928c17a2604b055dc193ce9380d49465c8a7e4df1e4bc2d1e7ec20d4baad3d99b35a30fbe0648438a3f5ab87c
          randwidth: 384
        }
        {
          name: RndCnstRandPerm
          desc: Compile-time random permutation for entropy used in share overriding
          type: keymgr_pkg::rand_perm_t
          randcount: 32
          randtype: perm
          name_top: RndCnstKeymgrRandPerm
          default: 0x5881e48e3cfb4980d1d9619f3ddd50a965dd58e8
          randwidth: 160
        }
        {
          name: RndCnstRevisionSeed
          desc: Compile-time random bits for revision seed
          type: keymgr_pkg::seed_t
          randcount: 256
          randtype: data
          name_top: RndCnstKeymgrRevisionSeed
          default: 0xd066a246fc2a434a06fe234ff960e41b65b7584f7737d5245de3aa56ec2ed286
          randwidth: 256
        }
        {
          name: RndCnstCreatorIdentitySeed
          desc: Compile-time random bits for creator identity seed
          type: keymgr_pkg::seed_t
          randcount: 256
          randtype: data
          name_top: RndCnstKeymgrCreatorIdentitySeed
          default: 0x44125c9cfe08a41eb8ccfdb584e284d5ce558a31e35cac26014d2a00d95e1941
          randwidth: 256
        }
        {
          name: RndCnstOwnerIntIdentitySeed
          desc: Compile-time random bits for owner intermediate identity seed
          type: keymgr_pkg::seed_t
          randcount: 256
          randtype: data
          name_top: RndCnstKeymgrOwnerIntIdentitySeed
          default: 0xd810ad586bc388bfc3857ee4700aac44f564d2de1a39d3535cfb6fdcdc67c339
          randwidth: 256
        }
        {
          name: RndCnstOwnerIdentitySeed
          desc: Compile-time random bits for owner identity seed
          type: keymgr_pkg::seed_t
          randcount: 256
          randtype: data
          name_top: RndCnstKeymgrOwnerIdentitySeed
          default: 0xaf6b0c9b1be2813823fed6ce8d66e72f5d928ec1ff39d8ac3d790314656c9224
          randwidth: 256
        }
        {
          name: RndCnstSoftOutputSeed
          desc: Compile-time random bits for software generation seed
          type: keymgr_pkg::seed_t
          randcount: 256
          randtype: data
          name_top: RndCnstKeymgrSoftOutputSeed
          default: 0x8e3faf2d0fb1130807540f978c3985aa5dc56c97ad06eaa1a353f5ccd09d08d
          randwidth: 256
        }
        {
          name: RndCnstHardOutputSeed
          desc: Compile-time random bits for hardware generation seed
          type: keymgr_pkg::seed_t
          randcount: 256
          randtype: data
          name_top: RndCnstKeymgrHardOutputSeed
          default: 0xaca4da1ce04622a516f03204a6cf4f764be25385c2e4b65c7145122d1f178635
          randwidth: 256
        }
        {
          name: RndCnstAesSeed
          desc: Compile-time random bits for generation seed when aes destination selected
          type: keymgr_pkg::seed_t
          randcount: 256
          randtype: data
          name_top: RndCnstKeymgrAesSeed
          default: 0xbe7732100161f6836716dda28ade994ba951abaea73474c935f38b06e26ee501
          randwidth: 256
        }
        {
          name: RndCnstKmacSeed
          desc: Compile-time random bits for generation seed when kmac destination selected
          type: keymgr_pkg::seed_t
          randcount: 256
          randtype: data
          name_top: RndCnstKeymgrKmacSeed
          default: 0x8eb82572f294146fa1a9e186a928511c23912dc0f873b5888667cd3fc5e46f47
          randwidth: 256
        }
        {
          name: RndCnstOtbnSeed
          desc: Compile-time random bits for generation seed when otbn destination selected
          type: keymgr_pkg::seed_t
          randcount: 256
          randtype: data
          name_top: RndCnstKeymgrOtbnSeed
          default: 0x6806081f0f9c493e7d3c4d9b8f06a276c465cd1de2293666ff419ceb5f2be43e
          randwidth: 256
        }
        {
          name: RndCnstCdi
          desc: Compile-time random bits for generation seed when no CDI is selected
          type: keymgr_pkg::seed_t
          randcount: 256
          randtype: data
          name_top: RndCnstKeymgrCdi
          default: 0x81db6846b60852d6fde65315d7269379bb12a4fb948d2dfa38f0097bb663417c
          randwidth: 256
        }
        {
          name: RndCnstNoneSeed
          desc: Compile-time random bits for generation seed when no destination selected
          type: keymgr_pkg::seed_t
          randcount: 256
          randtype: data
          name_top: RndCnstKeymgrNoneSeed
          default: 0x38536bb627237f3e663c21f0a0731d3380c3859bf6dd7882a7b894d1fd9b752b
          randwidth: 256
        }
      ]
    }
    {
      name: lc_ctrl
      type: lc_ctrl
      base_addrs:
      {
        regs:
        {
          hart: 0x40101000
        }
        dmi:
        {
          hart: 0x0
        }
      }
      memory: {}
      param_list:
      [
        {
          name: RndCnstLcKeymgrDivInvalid
          desc: Diversification value used for all invalid life cycle states.
          type: lc_ctrl_pkg::lc_keymgr_div_t
          randcount: 128
          randtype: data
          name_top: RndCnstLcCtrlLcKeymgrDivInvalid
          default: 0xd2e0cac7d5ab8c00a0c32582bbd38a46
          randwidth: 128
        }
        {
          name: RndCnstLcKeymgrDivTestUnlocked
          desc: Diversification value used for the TEST_UNLOCKED* life cycle states.
          type: lc_ctrl_pkg::lc_keymgr_div_t
          randcount: 128
          randtype: data
          name_top: RndCnstLcCtrlLcKeymgrDivTestUnlocked
          default: 0xc5443fec58ab9ca47c8222fbd165f019
          randwidth: 128
        }
        {
          name: RndCnstLcKeymgrDivDev
          desc: Diversification value used for the DEV life cycle state.
          type: lc_ctrl_pkg::lc_keymgr_div_t
          randcount: 128
          randtype: data
          name_top: RndCnstLcCtrlLcKeymgrDivDev
          default: 0x3a80420ef55d85257e09041806a51acc
          randwidth: 128
        }
        {
          name: RndCnstLcKeymgrDivProduction
          desc: Diversification value used for the PROD/PROD_END life cycle states.
          type: lc_ctrl_pkg::lc_keymgr_div_t
          randcount: 128
          randtype: data
          name_top: RndCnstLcCtrlLcKeymgrDivProduction
          default: 0xb201220ba92b551a3b9f9e9b2a72f277
          randwidth: 128
        }
        {
          name: RndCnstLcKeymgrDivRma
          desc: Diversification value used for the RMA life cycle state.
          type: lc_ctrl_pkg::lc_keymgr_div_t
          randcount: 128
          randtype: data
          name_top: RndCnstLcCtrlLcKeymgrDivRma
          default: 0x575653d8ea9cfe4df8d754d5cf7ac059
          randwidth: 128
        }
        {
          name: RndCnstInvalidTokens
          desc: Compile-time random bits used for invalid tokens in the token mux
          type: lc_ctrl_pkg::lc_token_mux_t
          randcount: 1024
          randtype: data
          name_top: RndCnstLcCtrlInvalidTokens
          default: 0xe13d1b1089fc8573678a5ab6202910ecd7f47d2ef871981817820657b57a05d9de74b56203a9475bf14f98c5d55a1813ca07703620424a2f5a7160496e7c0f8fbb9823a107a44d0c72081d8c7af4e3c5cf16cfbbd92bfd52c939d5a106614ec2459fc606d2055cfaabaea072bd4005bedb692fddf1641dac6111dba8eacba7db
          randwidth: 1024
        }
      ]
    }
    {
      name: alert_handler
      type: alert_handler
      base_addrs:
      {
        null:
        {
          hart: 0x40120000
        }
      }
      memory: {}
      param_list:
      [
        {
          name: RndCnstLfsrSeed
          desc: Compile-time random bits for initial LFSR seed
          type: alert_handler_pkg::lfsr_seed_t
          randcount: 32
          randtype: data
          name_top: RndCnstAlertHandlerLfsrSeed
          default: 0xbc1e20c1
          randwidth: 32
        }
        {
          name: RndCnstLfsrPerm
          desc: Compile-time random permutation for LFSR output
          type: alert_handler_pkg::lfsr_perm_t
          randcount: 32
          randtype: perm
          name_top: RndCnstAlertHandlerLfsrPerm
          default: 0x96c74d3d2c71330144b8fa3a03dd76e067e519b5
          randwidth: 160
        }
      ]
      template_type: alert_handler
    }
    {
      name: otp_ctrl
      type: otp_ctrl
      base_addrs:
      {
        core:
        {
          hart: 0x40130000
        }
      }
      memory: {}
      param_list:
      [
        {
          name: RndCnstLfsrSeed
          desc: Compile-time random bits for initial LFSR seed
          type: otp_ctrl_top_specific_pkg::lfsr_seed_t
          randcount: 40
          randtype: data
          name_top: RndCnstOtpCtrlLfsrSeed
          default: 0x1ada0d09dd
          randwidth: 40
        }
        {
          name: RndCnstLfsrPerm
          desc: Compile-time random permutation for LFSR output
          type: otp_ctrl_top_specific_pkg::lfsr_perm_t
          randcount: 40
          randtype: perm
          name_top: RndCnstOtpCtrlLfsrPerm
          default: 0x7d620161454649d99a8db0a07a738490570d0c74592cf4250132623215ca
          randwidth: 240
        }
        {
          name: RndCnstScrmblKeyInit
          desc: Compile-time random permutation for scrambling key/nonce register reset value
          type: otp_ctrl_top_specific_pkg::scrmbl_key_init_t
          randcount: 256
          randtype: data
          name_top: RndCnstOtpCtrlScrmblKeyInit
          default: 0x23c84b6940db545953533d2e520e455dba2e799b263e63fc8fbac9f4ac1af416
          randwidth: 256
        }
        {
          name: RndCnstScrmblKey0
          desc: Compile-time scrambling key
          type: otp_ctrl_top_specific_pkg::key_t
          randcount: 128
          randtype: extdata
          name_top: RndCnstOtpCtrlScrmblKey0
          default: 0x74df92d512a716c31dd891110fac9cd9
          randwidth: 128
        }
        {
          name: RndCnstScrmblKey1
          desc: Compile-time scrambling key
          type: otp_ctrl_top_specific_pkg::key_t
          randcount: 128
          randtype: extdata
          name_top: RndCnstOtpCtrlScrmblKey1
          default: 0xf4bf737470acf8643517d6c22764a4e9
          randwidth: 128
        }
        {
          name: RndCnstScrmblKey2
          desc: Compile-time scrambling key
          type: otp_ctrl_top_specific_pkg::key_t
          randcount: 128
          randtype: extdata
          name_top: RndCnstOtpCtrlScrmblKey2
          default: 0x139cf71c26ddc270805fcd8b1a9a5a59
          randwidth: 128
        }
        {
          name: RndCnstDigestConst0
          desc: Compile-time digest const
          type: otp_ctrl_top_specific_pkg::digest_const_t
          randcount: 128
          randtype: extdata
          name_top: RndCnstOtpCtrlDigestConst0
          default: 0x880645bfead231e406b46d1aea1289e4
          randwidth: 128
        }
        {
          name: RndCnstDigestConst1
          desc: Compile-time digest const
          type: otp_ctrl_top_specific_pkg::digest_const_t
          randcount: 128
          randtype: extdata
          name_top: RndCnstOtpCtrlDigestConst1
          default: 0xd72a835c11b550284a676d1c301c1aa5
          randwidth: 128
        }
        {
          name: RndCnstDigestConst2
          desc: Compile-time digest const
          type: otp_ctrl_top_specific_pkg::digest_const_t
          randcount: 128
          randtype: extdata
          name_top: RndCnstOtpCtrlDigestConst2
          default: 0x96315937b0ab7434f088ad19b129d24d
          randwidth: 128
        }
        {
          name: RndCnstDigestConst3
          desc: Compile-time digest const
          type: otp_ctrl_top_specific_pkg::digest_const_t
          randcount: 128
          randtype: extdata
          name_top: RndCnstOtpCtrlDigestConst3
          default: 0x8863d942a3dcf09c2d9f125380c59c33
          randwidth: 128
        }
        {
          name: RndCnstDigestIV0
          desc: Compile-time digest initial vector
          type: otp_ctrl_top_specific_pkg::digest_iv_t
          randcount: 64
          randtype: extdata
          name_top: RndCnstOtpCtrlDigestIV0
          default: 0xc3d4b116be4d7ae6
          randwidth: 64
        }
        {
          name: RndCnstDigestIV1
          desc: Compile-time digest initial vector
          type: otp_ctrl_top_specific_pkg::digest_iv_t
          randcount: 64
          randtype: extdata
          name_top: RndCnstOtpCtrlDigestIV1
          default: 0x34022b6c0d789cb3
          randwidth: 64
        }
        {
          name: RndCnstDigestIV2
          desc: Compile-time digest initial vector
          type: otp_ctrl_top_specific_pkg::digest_iv_t
          randcount: 64
          randtype: extdata
          name_top: RndCnstOtpCtrlDigestIV2
          default: 0x46949a331561c9ed
          randwidth: 64
        }
        {
          name: RndCnstDigestIV3
          desc: Compile-time digest initial vector
          type: otp_ctrl_top_specific_pkg::digest_iv_t
          randcount: 64
          randtype: extdata
          name_top: RndCnstOtpCtrlDigestIV3
          default: 0x69052d8845c62b58
          randwidth: 64
        }
        {
          name: RndCnstPartInvDefault
          desc: OTP invalid partition default for buffered partitions
          type: logic [16383:0]
          randcount: 16384
          randtype: extdata
          name_top: RndCnstOtpCtrlPartInvDefault
          default:
          [
            {
              size: 704
              items:
              [
                {
                  size: 320
                  inv_default: 437667205087615333188085628045866432397523039409444830296954128064190536456691943009486807979545
                }
                {
                  size: 384
                  inv_default: 32484060511911149636544393835225833781216059498095584554216928416534517374538477359017884198433181064965811067913132
                }
              ]
            }
            {
              size: 704
              items:
              [
                {
                  size: 64
                  inv_default: 3220005416749168533
                }
                {
                  size: 256
                  inv_default: 12874066877757179467650230033250684330563740985316953234135861337619123221457
                }
                {
                  size: 256
                  inv_default: 89754299710908028823207978994280084582357363874455887336697590830984911246409
                }
                {
                  size: 128
                  inv_default: 43607467814989757028965575194142311026
                }
              ]
            }
            {
              size: 704
              items:
              [
                {
                  size: 64
                  inv_default: 8810494674505979319
                }
                {
                  size: 128
                  inv_default: 319591236663997883296503332130008504071
                }
                {
                  size: 256
                  inv_default: 42067023397656232971303188458359095440464026953775379885125754893328795916837
                }
                {
                  size: 256
                  inv_default: 45468928134275788991545873869688826503719511575753596833096165248745999241720
                }
              ]
            }
            {
              size: 320
              items:
              [
                {
                  size: 64
                  inv_default: 5539200504167244868
                }
                {
                  size: 128
                  inv_default: 20677840707601421473471848780681763222
                }
                {
                  size: 128
                  inv_default: 208186818845381378382258058636907018373
                }
              ]
            }
            {
              size: 128
              items:
              [
                {
                  size: 64
                  inv_default: 10448389044042765021
                }
                {
                  comment: unallocated space
                  size: 40
                  inv_default: 0
                }
                {
                  size: 8
                  inv_default: 105
                }
                {
                  size: 8
                  inv_default: 105
                }
                {
                  size: 8
                  inv_default: 105
                }
              ]
            }
            {
              size: 576
              items:
              [
                {
                  size: 64
                  inv_default: 4145059766904508966
                }
                {
                  size: 256
                  inv_default: 44006333694227272956693949958715563173174492152061281456758559295070352469441
                }
                {
                  size: 256
                  inv_default: 52802220864608503837711356647287192946536634693415900517553687803248798893103
                }
              ]
            }
            {
              size: 320
              items:
              [
                {
                  size: 64
                  inv_default: 8230641386344453198
                }
                {
                  size: 32
                  inv_default: 0
                }
                {
                  size: 32
                  inv_default: 0
                }
                {
                  size: 32
                  inv_default: 0
                }
                {
                  size: 32
                  inv_default: 0
                }
                {
                  size: 32
                  inv_default: 0
                }
                {
                  size: 32
                  inv_default: 0
                }
                {
                  size: 32
                  inv_default: 0
                }
                {
                  size: 32
                  inv_default: 0
                }
              ]
            }
            {
              size: 3776
              items:
              [
                {
                  size: 64
                  inv_default: 10004875136179899350
                }
                {
                  size: 256
                  inv_default: 0
                }
                {
                  size: 32
                  inv_default: 0
                }
                {
                  size: 256
                  inv_default: 0
                }
                {
                  size: 32
                  inv_default: 0
                }
                {
                  size: 32
                  inv_default: 0
                }
                {
                  size: 256
                  inv_default: 0
                }
                {
                  size: 32
                  inv_default: 0
                }
                {
                  size: 32
                  inv_default: 0
                }
                {
                  size: 256
                  inv_default: 0
                }
                {
                  size: 32
                  inv_default: 0
                }
                {
                  size: 32
                  inv_default: 0
                }
                {
                  size: 256
                  inv_default: 0
                }
                {
                  size: 32
                  inv_default: 0
                }
                {
                  size: 512
                  inv_default: 0
                }
                {
                  size: 32
                  inv_default: 0
                }
                {
                  size: 512
                  inv_default: 0
                }
                {
                  size: 32
                  inv_default: 0
                }
                {
                  size: 512
                  inv_default: 0
                }
                {
                  size: 32
                  inv_default: 0
                }
                {
                  size: 512
                  inv_default: 0
                }
                {
                  size: 32
                  inv_default: 0
                }
              ]
            }
            {
              size: 5696
              items:
              [
                {
                  size: 64
                  inv_default: 17516780477869362820
                }
                {
                  comment: unallocated space
                  size: 96
                  inv_default: 0
                }
                {
                  size: 1024
                  inv_default: 0
                }
                {
                  size: 32
                  inv_default: 0
                }
                {
                  size: 32
                  inv_default: 0
                }
                {
                  size: 32
                  inv_default: 0
                }
                {
                  size: 32
                  inv_default: 0
                }
                {
                  size: 32
                  inv_default: 0
                }
                {
                  size: 96
                  inv_default: 0
                }
                {
                  size: 32
                  inv_default: 0
                }
                {
                  size: 32
                  inv_default: 0
                }
                {
                  size: 32
                  inv_default: 0
                }
                {
                  size: 32
                  inv_default: 0
                }
                {
                  size: 32
                  inv_default: 0
                }
                {
                  size: 32
                  inv_default: 0
                }
                {
                  size: 32
                  inv_default: 0
                }
                {
                  size: 32
                  inv_default: 0
                }
                {
                  size: 32
                  inv_default: 0
                }
                {
                  size: 512
                  inv_default: 0
                }
                {
                  size: 128
                  inv_default: 0
                }
                {
                  size: 128
                  inv_default: 0
                }
                {
                  size: 512
                  inv_default: 0
                }
                {
                  size: 2560
                  inv_default: 0
                }
                {
                  size: 32
                  inv_default: 0
                }
                {
                  size: 32
                  inv_default: 0
                }
                {
                  size: 32
                  inv_default: 0
                }
                {
                  size: 32
                  inv_default: 0
                }
              ]
            }
            {
              size: 2944
              items:
              [
                {
                  size: 64
                  inv_default: 6561794743094455431
                }
                {
                  comment: unallocated space
                  size: 96
                  inv_default: 0
                }
                {
                  size: 256
                  inv_default: 0
                }
                {
                  size: 256
                  inv_default: 0
                }
                {
                  size: 32
                  inv_default: 0
                }
                {
                  size: 32
                  inv_default: 0
                }
                {
                  size: 32
                  inv_default: 0
                }
                {
                  size: 32
                  inv_default: 0
                }
                {
                  size: 32
                  inv_default: 0
                }
                {
                  size: 32
                  inv_default: 0
                }
                {
                  size: 32
                  inv_default: 0
                }
                {
                  size: 32
                  inv_default: 0
                }
                {
                  size: 32
                  inv_default: 0
                }
                {
                  size: 32
                  inv_default: 0
                }
                {
                  size: 32
                  inv_default: 0
                }
                {
                  size: 32
                  inv_default: 0
                }
                {
                  size: 32
                  inv_default: 0
                }
                {
                  size: 32
                  inv_default: 0
                }
                {
                  size: 32
                  inv_default: 0
                }
                {
                  size: 32
                  inv_default: 0
                }
                {
                  size: 32
                  inv_default: 0
                }
                {
                  size: 32
                  inv_default: 0
                }
                {
                  size: 32
                  inv_default: 0
                }
                {
                  size: 32
                  inv_default: 0
                }
                {
                  size: 32
                  inv_default: 0
                }
                {
                  size: 32
                  inv_default: 0
                }
                {
                  size: 32
                  inv_default: 0
                }
                {
                  size: 32
                  inv_default: 0
                }
                {
                  size: 32
                  inv_default: 0
                }
                {
                  size: 32
                  inv_default: 0
                }
                {
                  size: 32
                  inv_default: 0
                }
                {
                  size: 32
                  inv_default: 0
                }
                {
                  size: 32
                  inv_default: 0
                }
                {
                  size: 32
                  inv_default: 0
                }
                {
                  size: 32
                  inv_default: 0
                }
                {
                  size: 32
                  inv_default: 0
                }
                {
                  size: 1248
                  inv_default: 0
                }
              ]
            }
            {
              size: 512
              items:
              [
                {
                  size: 64
                  inv_default: 8179192855524638234
                }
                {
                  size: 448
                  inv_default: 0
                }
              ]
            }
          ]
          randwidth: 16384
        }
      ]
      template_type: otp_ctrl
      otp_mmap:
      {
        otp:
        {
          width: 2
          depth: 1024
          size: 2048
          addr_width: 10
          byte_addr_width: 11
        }
        scrambling:
        {
          key_size: 16
          iv_size: 8
          cnst_size: 16
          keys:
          [
            {
              name: Secret0Key
              value: 155351307823676984780177923536797342937
            }
            {
              name: Secret1Key
              value: 325325701373942325998692447788321776873
            }
            {
              name: Secret2Key
              value: 26070342215434008250948555945748879961
            }
          ]
          digests:
          [
            {
              name: CnstyDigest
              iv_value: 14111098243698752230
              cnst_value: 180807575899415062193048934552414882276
            }
            {
              name: FlashDataKey
              iv_value: 3747605583008144563
              cnst_value: 286004759851944844388724274920247007909
            }
            {
              name: FlashAddrKey
              iv_value: 5085859423400872429
              cnst_value: 199640431460485887587361184200436339277
            }
            {
              name: SramDataKey
              iv_value: 7567504812175403864
              cnst_value: 181293451378399381534200352299121220659
            }
          ]
          num_keys: 3
          num_digests: 4
        }
        partitions:
        [
          {
            name: VENDOR_TEST
            variant: Unbuffered
            secret: false
            sw_digest: true
            hw_digest: false
            write_lock: Digest
            read_lock: CSR
            key_sel: NoKey
            integrity: false
            bkout_type: false
            skip_sw_header: true
            items:
            [
              {
                name: SCRATCH
                size: 56
                isdigest: false
                iszer: false
                ismubi: false
                iskeymgr_creator: false
                iskeymgr_owner: false
                inv_default: 0
                offset: 0
              }
              {
                name: VENDOR_TEST_DIGEST
                size: 8
                offset: 56
                ismubi: false
                isdigest: true
                iszer: false
                inv_default: 8179192855524638234
                iskeymgr_creator: false
                iskeymgr_owner: false
              }
            ]
            desc:
              '''
              Vendor test partition.
              This is reserved for manufacturing smoke checks. The OTP wrapper
              control logic inside otp_macro is allowed to read/write to this
              region. ECC uncorrectable errors seen on the functional otp_macro
              interface will not lead to an alert for this partition.
              Instead, such errors will be reported as correctable ECC errors.
              '''
            absorb: false
            iskeymgr_creator: false
            iskeymgr_owner: false
            zeroizable: false
            ignore_read_lock_in_rma: false
            size: 64
            offset: 0
          }
          {
            name: CREATOR_SW_CFG
            variant: Unbuffered
            absorb: true
            secret: false
            sw_digest: true
            hw_digest: false
            write_lock: Digest
            read_lock: CSR
            key_sel: NoKey
            integrity: true
            bkout_type: false
            items:
            [
              {
                name: CREATOR_SW_CFG_AST_CFG
                size: 156
                desc:
                  '''
                  AST configuration data. These values get blindly copied to
                  the AST CSRs during ROM execution.
                  '''
                isdigest: false
                iszer: false
                ismubi: false
                iskeymgr_creator: false
                iskeymgr_owner: false
                inv_default: 0
                offset: 64
              }
              {
                name: CREATOR_SW_CFG_AST_INIT_EN
                size: 4
                desc:
                  '''
                  Controls whether or not the CREATOR_SW_CFG_AST_CFG values
                  get copied to the AST CSRs during ROM execution.
                  A value of kMultiBitBool4True enables copying; all other
                  values disable.
                  '''
                isdigest: false
                iszer: false
                ismubi: false
                iskeymgr_creator: false
                iskeymgr_owner: false
                inv_default: 0
                offset: 220
              }
              {
                name: CREATOR_SW_CFG_ROM_EXT_SKU
                size: 4
                desc: SKU identifier metadata. Unused by SiliconCreator software.
                isdigest: false
                iszer: false
                ismubi: false
                iskeymgr_creator: false
                iskeymgr_owner: false
                inv_default: 0
                offset: 224
              }
              {
                name: CREATOR_SW_CFG_SIGVERIFY_SPX_EN
                size: 4
                desc:
                  '''
                  Controls whether or not SPHINCS+ signature verification will
                  be executed when the ROM attempts to boot the ROM_EXT.
                  A value of kSigverifySpxDisabledOtp disables SPHINCS+
                  signature verification, while all other values enable it.
                  Note, SPHINCS+ signature verification is always disabled in
                  TEST_UNLOCKED* LC states.
                  '''
                isdigest: false
                iszer: false
                ismubi: false
                iskeymgr_creator: false
                iskeymgr_owner: false
                inv_default: 0
                offset: 228
              }
              {
                name: CREATOR_SW_CFG_FLASH_DATA_DEFAULT_CFG
                size: 4
                desc:
                  '''
                  The default scrambling, ECC, and high endurance
                  configuration settings for flash data pages set during ROM
                  execution.
                  '''
                isdigest: false
                iszer: false
                ismubi: false
                iskeymgr_creator: false
                iskeymgr_owner: false
                inv_default: 0
                offset: 232
              }
              {
                name: CREATOR_SW_CFG_FLASH_INFO_BOOT_DATA_CFG
                size: 4
                desc:
                  '''
                  The scrambling, ECC, and high endurance configuration
                  settings for the boot data flash info pages set during ROM
                  execution.
                  '''
                isdigest: false
                iszer: false
                ismubi: false
                iskeymgr_creator: false
                iskeymgr_owner: false
                inv_default: 0
                offset: 236
              }
              {
                name: CREATOR_SW_CFG_FLASH_HW_INFO_CFG_OVERRIDE
                size: 4
                desc:
                  '''
                  Scrambling and ECC configuration overrides (set by the ROM)
                  for the Creator and OwnerSeed flash info pages (pages 1 and
                  2 in partition 0) that are hardwired to the keygmr. By
                  default, scrambling and ECC on these flash info pages must
                  be enabled in order to successfully crank the keygmr (in the
                  ROM_EXT). However, values of kMultiBitBool4True for each
                  subfield in this field will disable this requirement. See
                  the HW_INFO_CFG_OVERRIDE flash_ctrl CSR for more details.
                  '''
                isdigest: false
                iszer: false
                ismubi: false
                iskeymgr_creator: false
                iskeymgr_owner: false
                inv_default: 0
                offset: 240
              }
              {
                name: CREATOR_SW_CFG_RNG_EN
                size: 4
                desc:
                  '''
                  Whether or not to enable use of hardware generated entropy
                  (from the entropy complex via EDN) in the `rnd_uint32`
                  function. A value of kHardenedBoolTrue enables the use of
                  hardware generated entropy, while all other values disable.
                  '''
                isdigest: false
                iszer: false
                ismubi: false
                iskeymgr_creator: false
                iskeymgr_owner: false
                inv_default: 0
                offset: 244
              }
              {
                name: CREATOR_SW_CFG_JITTER_EN
                size: 4
                desc:
                  '''
                  Whether or not to enable clock jitter. A value of
                  kMultiBitBool4False disables, while all other values enable.
                  '''
                isdigest: false
                iszer: false
                ismubi: false
                iskeymgr_creator: false
                iskeymgr_owner: false
                inv_default: 0
                offset: 248
              }
              {
                name: CREATOR_SW_CFG_RET_RAM_RESET_MASK
                size: 4
                desc:
                  '''
                  Reset reason mask used to initialize (by overwriting with
                  random data) retention SRAM during ROM execution. A value of
                  0 only initializes retention SRAM on power-on-resets.See
                  rstmgr RESET_INFO CSR documentation for more details.
                  '''
                isdigest: false
                iszer: false
                ismubi: false
                iskeymgr_creator: false
                iskeymgr_owner: false
                inv_default: 0
                offset: 252
              }
              {
                name: CREATOR_SW_CFG_MANUF_STATE
                size: 4
                desc:
                  '''
                  Manufacturing state binding field. For use by
                  SiliconCreators or SiliconOwners to bind ROM_EXT images to a
                  specific device or set of devices.
                  '''
                isdigest: false
                iszer: false
                ismubi: false
                iskeymgr_creator: false
                iskeymgr_owner: false
                inv_default: 0
                offset: 256
              }
              {
                name: CREATOR_SW_CFG_ROM_EXEC_EN
                size: 4
                desc:
                  '''
                  Whether or not to enable execution of ROM. A value of 0
                  disables, while all other values enable. This enables
                  provisioning flows to attach JTAG connections and halt the
                  CPU before the device has been fully provisioned. All SKUs
                  should set this field to a non-zero value. Provisioning
                  flows shall take care to program this field at the
                  appropriate time during.
                  '''
                isdigest: false
                iszer: false
                ismubi: false
                iskeymgr_creator: false
                iskeymgr_owner: false
                inv_default: 0
                offset: 260
              }
              {
                name: CREATOR_SW_CFG_CPUCTRL
                size: 4
                desc:
                  '''
                  Value to write to the Ibex CPUCTRL CSR during ROM execution.
                  This field controls settings such as ICACHE enablement. See
                  Ibex documentation for more information.
                  '''
                isdigest: false
                iszer: false
                ismubi: false
                iskeymgr_creator: false
                iskeymgr_owner: false
                inv_default: 0
                offset: 264
              }
              {
                name: CREATOR_SW_CFG_MIN_SEC_VER_ROM_EXT
                size: 4
                desc:
                  '''
                  Value of the min_security_version_rom_ext field of the
                  default boot data.
                  '''
                isdigest: false
                iszer: false
                ismubi: false
                iskeymgr_creator: false
                iskeymgr_owner: false
                inv_default: 0
                offset: 268
              }
              {
                name: CREATOR_SW_CFG_MIN_SEC_VER_BL0
                size: 4
                desc:
                  '''
                  Value of the min_security_version_bl0 field of the
                  default boot data.
                  '''
                isdigest: false
                iszer: false
                ismubi: false
                iskeymgr_creator: false
                iskeymgr_owner: false
                inv_default: 0
                offset: 272
              }
              {
                name: CREATOR_SW_CFG_DEFAULT_BOOT_DATA_IN_PROD_EN
                size: 4
                desc:
                  '''
                  Whether or not to enable the default boot data in PROD and
                  PROD_END life cycle states. A value of kHardenedBoolTrue
                  enables, all other values disable. If left disabled,
                  provisioning flows are required to setup boot data pages
                  prior to enabling ROM execution. The default personalization
                  flow in `ft_personalize.c` configures these pages.
                  '''
                isdigest: false
                iszer: false
                ismubi: false
                iskeymgr_creator: false
                iskeymgr_owner: false
                inv_default: 0
                offset: 276
              }
              {
                name: CREATOR_SW_CFG_RMA_SPIN_EN
                size: 4
                desc:
                  '''
                  Whether or not to enable a busy-wait delay loop in the ROM,
                  when a specific SW strapping configuration is applied during
                  boot, to provide time to trigger an RMA lifecycle transition
                  over JTAG. A value of kHardenedBoolTrue enables, all other
                  values disable.
                  '''
                isdigest: false
                iszer: false
                ismubi: false
                iskeymgr_creator: false
                iskeymgr_owner: false
                inv_default: 0
                offset: 280
              }
              {
                name: CREATOR_SW_CFG_RMA_SPIN_CYCLES
                size: 4
                desc:
                  '''
                  The number of Ibex clock cycles to spin for when waiting for
                  an RMA transition. Used in combination with the
                  CREATOR_SW_CFG_RMA_SPIN_EN field.
                  '''
                isdigest: false
                iszer: false
                ismubi: false
                iskeymgr_creator: false
                iskeymgr_owner: false
                inv_default: 0
                offset: 284
              }
              {
                name: CREATOR_SW_CFG_RNG_REPCNT_THRESHOLDS
                size: 4
                desc:
                  '''
                  The repetition count health test thresholds to enable
                  entropy_src with during ROM execution.
                  This must be configured if CREATOR_SW_CFG_RNG_EN is true.
                  See entropy_src documentation for more details.
                  '''
                isdigest: false
                iszer: false
                ismubi: false
                iskeymgr_creator: false
                iskeymgr_owner: false
                inv_default: 0
                offset: 288
              }
              {
                name: CREATOR_SW_CFG_RNG_REPCNTS_THRESHOLDS
                size: 4
                desc:
                  '''
                  The repetition count symbol health test thresholds to enable
                  entropy_src with during ROM execution.
                  This must be configured if CREATOR_SW_CFG_RNG_EN is true.
                  See entropy_src documentation for more details.
                  '''
                isdigest: false
                iszer: false
                ismubi: false
                iskeymgr_creator: false
                iskeymgr_owner: false
                inv_default: 0
                offset: 292
              }
              {
                name: CREATOR_SW_CFG_RNG_ADAPTP_HI_THRESHOLDS
                size: 4
                desc:
                  '''
                  The adaptive proportion health test high thresholds to
                  enable entropy_src with during ROM execution.
                  This must be configured if CREATOR_SW_CFG_RNG_EN is true.
                  See entropy_src documentation for more details.
                  '''
                isdigest: false
                iszer: false
                ismubi: false
                iskeymgr_creator: false
                iskeymgr_owner: false
                inv_default: 0
                offset: 296
              }
              {
                name: CREATOR_SW_CFG_RNG_ADAPTP_LO_THRESHOLDS
                size: 4
                desc:
                  '''
                  The adaptive proportion health test low thresholds to enable
                  entropy_src with during ROM execution.
                  This must be configured if CREATOR_SW_CFG_RNG_EN is true.
                  See entropy_src documentation for more details.
                  '''
                isdigest: false
                iszer: false
                ismubi: false
                iskeymgr_creator: false
                iskeymgr_owner: false
                inv_default: 0
                offset: 300
              }
              {
                name: CREATOR_SW_CFG_RNG_BUCKET_THRESHOLDS
                size: 4
                desc:
                  '''
                  The bucket health test thresholds to enable entropy_src with
                  during ROM execution.
                  This must be configured if CREATOR_SW_CFG_RNG_EN is true.
                  See entropy_src documentation for more details.
                  '''
                isdigest: false
                iszer: false
                ismubi: false
                iskeymgr_creator: false
                iskeymgr_owner: false
                inv_default: 0
                offset: 304
              }
              {
                name: CREATOR_SW_CFG_RNG_MARKOV_HI_THRESHOLDS
                size: 4
                desc:
                  '''
                  The Markov health test high thresholds to enable entropy_src
                  with during ROM execution.
                  This must be configured if CREATOR_SW_CFG_RNG_EN is true.
                  See entropy_src documentation for more details.
                  '''
                isdigest: false
                iszer: false
                ismubi: false
                iskeymgr_creator: false
                iskeymgr_owner: false
                inv_default: 0
                offset: 308
              }
              {
                name: CREATOR_SW_CFG_RNG_MARKOV_LO_THRESHOLDS
                size: 4
                desc:
                  '''
                  The Markov health test low thresholds to enable entropy_src
                  with during ROM execution.
                  This must be configured if CREATOR_SW_CFG_RNG_EN is true.
                  See entropy_src documentation for more details.
                  '''
                isdigest: false
                iszer: false
                ismubi: false
                iskeymgr_creator: false
                iskeymgr_owner: false
                inv_default: 0
                offset: 312
              }
              {
                name: CREATOR_SW_CFG_RNG_EXTHT_HI_THRESHOLDS
                size: 4
                desc:
                  '''
                  The external health test high thresholds to enable the
                  entropy_src with during ROM execution.
                  This must be configured if CREATOR_SW_CFG_RNG_EN is true.
                  See entropy_src documentation for more details.
                  '''
                isdigest: false
                iszer: false
                ismubi: false
                iskeymgr_creator: false
                iskeymgr_owner: false
                inv_default: 0
                offset: 316
              }
              {
                name: CREATOR_SW_CFG_RNG_EXTHT_LO_THRESHOLDS
                size: 4
                desc:
                  '''
                  The external health test low thresholds to enable the
                  entropy_src with during ROM execution.
                  This must be configured if CREATOR_SW_CFG_RNG_EN is true.
                  See entropy_src documentation for more details.
                  '''
                isdigest: false
                iszer: false
                ismubi: false
                iskeymgr_creator: false
                iskeymgr_owner: false
                inv_default: 0
                offset: 320
              }
              {
                name: CREATOR_SW_CFG_RNG_ALERT_THRESHOLD
                size: 4
                desc:
                  '''
                  The alert threshold to configure the entropy_src with during
                  ROM execution.
                  This must be configured if CREATOR_SW_CFG_RNG_EN is true.
                  See entropy_src documentation for more details.
                  '''
                isdigest: false
                iszer: false
                ismubi: false
                iskeymgr_creator: false
                iskeymgr_owner: false
                inv_default: 0
                offset: 324
              }
              {
                name: CREATOR_SW_CFG_RNG_HEALTH_CONFIG_DIGEST
                size: 4
                desc:
                  '''
                  A CRC32 digest of all entropy_src health test threshold
                  configuration fields above.
                  This must be configured if CREATOR_SW_CFG_RNG_EN is true.
                  See entropy_src documentation for more details.
                  '''
                isdigest: false
                iszer: false
                ismubi: false
                iskeymgr_creator: false
                iskeymgr_owner: false
                inv_default: 0
                offset: 328
              }
              {
                name: CREATOR_SW_CFG_SRAM_KEY_RENEW_AND_INIT_EN
                size: 4
                desc:
                  '''
                  Whether or not the ROM should request SRAM to be rescrambled
                  with a new key on every boot. This includes renewing the
                  scrambling key and then initializing SRAM with pseudo-random
                  data. kHardenedBoolFalse disables, while all other values
                  enable.
                  '''
                isdigest: false
                iszer: false
                ismubi: false
                iskeymgr_creator: false
                iskeymgr_owner: false
                inv_default: 0
                offset: 332
              }
              {
                name: CREATOR_SW_CFG_IMMUTABLE_ROM_EXT_EN
                size: 4
                desc:
                  '''
                  Enablement of the ROM_EXT immutable code section.
                  A value of kHardenedBoolTrue enables the feature.
                  All other values disable it.
                  '''
                isdigest: false
                iszer: false
                ismubi: false
                iskeymgr_creator: false
                iskeymgr_owner: false
                inv_default: 0
                offset: 336
              }
              {
                name: CREATOR_SW_CFG_IMMUTABLE_ROM_EXT_START_OFFSET
                size: 4
                desc:
                  '''
                  Relative offset from the start of the ROM_EXT slot to
                  find the immutable code section at.
                  '''
                isdigest: false
                iszer: false
                ismubi: false
                iskeymgr_creator: false
                iskeymgr_owner: false
                inv_default: 0
                offset: 340
              }
              {
                name: CREATOR_SW_CFG_IMMUTABLE_ROM_EXT_LENGTH
                size: 4
                desc: Length (in bytes) of the immutable code section.
                isdigest: false
                iszer: false
                ismubi: false
                iskeymgr_creator: false
                iskeymgr_owner: false
                inv_default: 0
                offset: 344
              }
              {
                name: CREATOR_SW_CFG_IMMUTABLE_ROM_EXT_SHA256_HASH
                size: 32
                desc: SHA256 hash of the immutable ROM_EXT section.
                isdigest: false
                iszer: false
                ismubi: false
                iskeymgr_creator: false
                iskeymgr_owner: false
                inv_default: 0
                offset: 348
              }
              {
                name: CREATOR_SW_CFG_RESERVED
                size: 32
                desc:
                  '''
                  Unused bits in the CREATOR_SW_CFG OTP partition. These can
                  be claimed by software as needed.
                  '''
                isdigest: false
                iszer: false
                ismubi: false
                iskeymgr_creator: false
                iskeymgr_owner: false
                inv_default: 0
                offset: 380
              }
              {
                name: CREATOR_SW_CFG_DIGEST
                size: 8
                offset: 424
                ismubi: false
                isdigest: true
                iszer: false
                inv_default: 6561794743094455431
                iskeymgr_creator: false
                iskeymgr_owner: false
              }
            ]
            desc:
              '''
              Software configuration partition.
              This is for device-specific calibration data, e.g, clock, LDO, RNG,
              and configuration settings set by the ROM.
              '''
            iskeymgr_creator: false
            iskeymgr_owner: false
            zeroizable: false
            ignore_read_lock_in_rma: false
            size: 368
            offset: 64
          }
          {
            name: OWNER_SW_CFG
            variant: Unbuffered
            absorb: true
            secret: false
            sw_digest: true
            hw_digest: false
            write_lock: Digest
            read_lock: CSR
            key_sel: NoKey
            integrity: true
            bkout_type: false
            items:
            [
              {
                name: OWNER_SW_CFG_ROM_ERROR_REPORTING
                size: 4
                desc:
                  '''
                  The shutdown error reporting verbosity used by the ROM.
                  Should be configured to one of several
                  `shutdown_error_redact_t` values. See
                  `sw/device/silicon_creator/lib/shutdown.h` for more details.
                  '''
                isdigest: false
                iszer: false
                ismubi: false
                iskeymgr_creator: false
                iskeymgr_owner: false
                inv_default: 0
                offset: 432
              }
              {
                name: OWNER_SW_CFG_ROM_BOOTSTRAP_DIS
                size: 4
                desc:
                  '''
                  Whether or not to disable ROM bootstrap mechanism. A value
                  of kHardenedBoolTrue disable bootstrap mechanism in the ROM,
                  while all other values enable it. Note, the provisioning
                  flow should take care when to program this field if it is
                  used by a SKU, as there is no way to get firmware into flash
                  in a PROD LC state if a valid ROM_EXT does not already exist
                  in flash once this value is configured to true.
                  '''
                isdigest: false
                iszer: false
                ismubi: false
                iskeymgr_creator: false
                iskeymgr_owner: false
                inv_default: 0
                offset: 436
              }
              {
                name: OWNER_SW_CFG_ROM_ALERT_CLASS_EN
                size: 4
                desc:
                  '''
                  A four byte packed field, where each byte controls whether
                  or not the ROM enables each alert class (A through D) of the
                  alert_handler. The byte-sized subfields are arranged from D
                  to A, MSB to LSB. Each byte should be set to an
                  `alert_enable_t` value accordingly. See the alert_handler
                  documentation for more details.
                  '''
                isdigest: false
                iszer: false
                ismubi: false
                iskeymgr_creator: false
                iskeymgr_owner: false
                inv_default: 0
                offset: 440
              }
              {
                name: OWNER_SW_CFG_ROM_ALERT_ESCALATION
                size: 4
                desc:
                  '''
                  A four byte packed field, where each byte controls the
                  escalation configuration for each alert class (A through D)
                  of the alert_handler configured by the ROM. The byte-sized
                  subfields are arranged from D to A, MSB to LSB. Each byte
                  should be set to an `alert_escalate_t` value accordingly.
                  See the alert_handler documentation for more details.
                  '''
                isdigest: false
                iszer: false
                ismubi: false
                iskeymgr_creator: false
                iskeymgr_owner: false
                inv_default: 0
                offset: 444
              }
              {
                name: OWNER_SW_CFG_ROM_ALERT_CLASSIFICATION
                size: 320
                desc:
                  '''
                  The alert classifications (A through D) for each alert
                  source of the alert_handler to be configured by the ROM. The
                  field consists of a contiguous 320-byte block, or 80 32-bit
                  words. The four bytes in each word encode the configuration
                  of a single alert source across four lifecycle states, in
                  order from LSB to MSB: PROD, PROD_END, DEV, and RMA. Each
                  byte should be set to an `alert_class_t` value accordingly.
                  The order of the 80 32-bit words, from LSB to MSB can be
                  found in the EARLGREY_ALERTS list in `rules/const.bzl`.
                  See the alert_handler documentation for more details.
                  '''
                isdigest: false
                iszer: false
                ismubi: false
                iskeymgr_creator: false
                iskeymgr_owner: false
                inv_default: 0
                offset: 448
              }
              {
                name: OWNER_SW_CFG_ROM_LOCAL_ALERT_CLASSIFICATION
                size: 64
                desc:
                  '''
                  Same as the `OWNER_SW_CFG_ROM_ALERT_CLASSIFICATION` field,
                  except these configuration correspond to the local alert
                  sources found in the `EARLGREY_LOC_ALERTS list in
                  `rules/const.bzl`.
                  '''
                isdigest: false
                iszer: false
                ismubi: false
                iskeymgr_creator: false
                iskeymgr_owner: false
                inv_default: 0
                offset: 768
              }
              {
                name: OWNER_SW_CFG_ROM_ALERT_ACCUM_THRESH
                size: 16
                desc:
                  '''
                  The alert accumulation threshold values for each alert class
                  (A through D) of the alert_handler to be configured by the
                  ROM. This field consists of four 32-bit words encoding the
                  accumulation thresholds for each alert class A through D
                  arranged LSW to MSW. See the alert_handler documentation for
                  more details.
                  '''
                isdigest: false
                iszer: false
                ismubi: false
                iskeymgr_creator: false
                iskeymgr_owner: false
                inv_default: 0
                offset: 832
              }
              {
                name: OWNER_SW_CFG_ROM_ALERT_TIMEOUT_CYCLES
                size: 16
                desc:
                  '''
                  Same as the `OWNER_SW_CFG_ROM_ALERT_ACCUM_THRESH` field,
                  except each value corresponds to the interrupt timeout
                  configuration of an alert class.
                  '''
                isdigest: false
                iszer: false
                ismubi: false
                iskeymgr_creator: false
                iskeymgr_owner: false
                inv_default: 0
                offset: 848
              }
              {
                name: OWNER_SW_CFG_ROM_ALERT_PHASE_CYCLES
                size: 64
                desc:
                  '''
                  The alert escalation phase durations, measured in clock
                  cycles, the ROM will configure the four alert phases for
                  each alert class of the alert_handler. This field consists
                  of a contiguous 64-byte block, or an array of four 128-bit
                  fields. Each 128-bit subfield encodes four 32-bit words that
                  contain the alert phase cycle count configurations for alert
                  escalation phases 0 to 3, from LSW to MSW. Each 128-bit
                  subfield is contains all configurations for a single alert
                  class, arranged from class A to D, from LS to MS. For
                  example, the cycle durations of each escalation phase in
                  this field should be configured as such, from LSB to MSB:
                  <classA,phase0>...<classA,phase3>...<classD,phase0>...
                  <classD,phase3>. See the alert_handler documentation for
                  more details.
                  '''
                isdigest: false
                iszer: false
                ismubi: false
                iskeymgr_creator: false
                iskeymgr_owner: false
                inv_default: 0
                offset: 864
              }
              {
                name: OWNER_SW_CFG_ROM_ALERT_DIGEST_PROD
                size: 4
                desc:
                  '''
                  The expected CRC32 digest over all of the alert_handler
                  configurations set up by the ROM for a device operating in
                  the PROD LC state. The ROM reads this field and checks it
                  against a digest it computes over the alert_handler
                  configuration it programmed. This field is expected to be
                  automatically computed by the `otp_alert_digest()` Bazel
                  rule. See the `alert_config_crc32()` function in the
                  SiliconCreator alert_handler driver for more details on what
                  configurations are included in this digest.
                  '''
                isdigest: false
                iszer: false
                ismubi: false
                iskeymgr_creator: false
                iskeymgr_owner: false
                inv_default: 0
                offset: 928
              }
              {
                name: OWNER_SW_CFG_ROM_ALERT_DIGEST_PROD_END
                size: 4
                desc:
                  '''
                  Same as the `OWNER_SW_CFG_ROM_ALERT_DIGEST_PROD` field,
                  except the expected digest is for chips operating in the
                  PROD_END LC state.
                  '''
                isdigest: false
                iszer: false
                ismubi: false
                iskeymgr_creator: false
                iskeymgr_owner: false
                inv_default: 0
                offset: 932
              }
              {
                name: OWNER_SW_CFG_ROM_ALERT_DIGEST_DEV
                size: 4
                desc:
                  '''
                  Same as the `OWNER_SW_CFG_ROM_ALERT_DIGEST_PROD` field,
                  except the expected digest is for chips operating in the
                  DEV LC state.
                  '''
                isdigest: false
                iszer: false
                ismubi: false
                iskeymgr_creator: false
                iskeymgr_owner: false
                inv_default: 0
                offset: 936
              }
              {
                name: OWNER_SW_CFG_ROM_ALERT_DIGEST_RMA
                size: 4
                desc:
                  '''
                  Same as the `OWNER_SW_CFG_ROM_ALERT_DIGEST_PROD` field,
                  except the expected digest is for chips operating in the
                  RMA LC state.
                  '''
                isdigest: false
                iszer: false
                ismubi: false
                iskeymgr_creator: false
                iskeymgr_owner: false
                inv_default: 0
                offset: 940
              }
              {
                name: OWNER_SW_CFG_ROM_WATCHDOG_BITE_THRESHOLD_CYCLES
                size: 4
                desc: Watchdog timer bite threshold (in cycles) configured by the ROM.
                isdigest: false
                iszer: false
                ismubi: false
                iskeymgr_creator: false
                iskeymgr_owner: false
                inv_default: 0
                offset: 944
              }
              {
                name: OWNER_SW_CFG_ROM_KEYMGR_OTP_MEAS_EN
                size: 4
                desc:
                  '''
                  Whether or not to configure the attestation SW binding CSRs
                  of the keymgr with the value in ROM_EXT manifest or the
                  measurement of the OTP CreatorSwCfg, OwnerSwCfg, and
                  secure boot key integrity digest. A value of
                  kHardenedBoolTrue uses the ROM computed OTP measurements,
                  while all other values trigger the use of the binding values
                  included in the ROM_EXT manifest.
                  '''
                isdigest: false
                iszer: false
                ismubi: false
                iskeymgr_creator: false
                iskeymgr_owner: false
                inv_default: 0
                offset: 948
              }
              {
                name: OWNER_SW_CFG_MANUF_STATE
                size: 4
                desc:
                  '''
                  Manufacturing state binding field. For use by
                  SiliconCreators or SiliconOwners to bind BL0 images to a
                  specific device or set of devices.
                  '''
                isdigest: false
                iszer: false
                ismubi: false
                iskeymgr_creator: false
                iskeymgr_owner: false
                inv_default: 0
                offset: 952
              }
              {
                name: OWNER_SW_CFG_ROM_RSTMGR_INFO_EN
                size: 4
                desc:
                  '''
                  A two byte packed word that indicates the expected rstmgr
                  alert and CPU info dump enable states, configured in the
                  rstmgr's ALERT_INFO_CTRL and CPU_INFO_CTRL CSRs respectively.
                  The expected format of this fields is
                  {0,0,kHardenedBool*,kHardenedBool*}, read MSB to LSB, where
                  the left most kHardenedBool* entry indicates the expected
                  enablement state of the ALERT_INFO_CTRL, and the right most
                  indicates the enablement state of the CPU_INFO_CTRL. Since
                  the ROM expects both to be disabled upon handing over
                  execution control to the ROM_EXT, this entire OTP field
                  **should be left unprovisioned, or set to all 0**.
                  '''
                isdigest: false
                iszer: false
                ismubi: false
                iskeymgr_creator: false
                iskeymgr_owner: false
                inv_default: 0
                offset: 956
              }
              {
                name: OWNER_SW_CFG_ROM_EXT_BOOTSTRAP_EN
                size: 4
                desc: Unused. Set to 0.
                isdigest: false
                iszer: false
                ismubi: false
                iskeymgr_creator: false
                iskeymgr_owner: false
                inv_default: 0
                offset: 960
              }
              {
                name: OWNER_SW_CFG_ROM_SENSOR_CTRL_ALERT_CFG
                size: 12
                desc:
                  '''
                  Alert configuration values for the sensor_ctrl block
                  that will be configured by the ROM. This field is 12 bytes
                  long, where each byte contains two 4-bit packed subfields,
                  encoding two four bit boolean values (kMultiBitBool4False or
                  kMultiBitBool4True), as follows (read MSB to LSB):
                  {fatality, enablement}. For example, the byte 0x69 would
                  encode the alert is: 1) recoverable, and 2) disabled.

                  Currently, there are only 11 alerts in sensor_ctrl to
                  configure, thus only the least significant bytes in this
                  field are used.
                  '''
                isdigest: false
                iszer: false
                ismubi: false
                iskeymgr_creator: false
                iskeymgr_owner: false
                inv_default: 0
                offset: 964
              }
              {
                name: OWNER_SW_CFG_ROM_SRAM_READBACK_EN
                size: 4
                desc:
                  '''
                  This field encodes the enablements of the readback security
                  features for the main and retention SRAMs to be configured
                  by the ROM. This field is four bytes, but the LSB contains
                  two 4-bit packed kMultiBitBool4* values that indicate the
                  enablement of the feature for the retention SRAM and
                  main SRAM, from MSB to LSB respectively. See the READBACK
                  CSR of the sram_ctrl for more details on this feature.
                  '''
                isdigest: false
                iszer: false
                ismubi: false
                iskeymgr_creator: false
                iskeymgr_owner: false
                inv_default: 0
                offset: 976
              }
              {
                name: OWNER_SW_CFG_ROM_PRESERVE_RESET_REASON_EN
                size: 4
                desc:
                  '''
                  Whether or not the ROM should preserve the reset reasons CSR
                  state in the rstmgr, or clear it. A value of
                  kHardenedBoolTrue preserves the CSR, while other values
                  trigger the ROM to clear the CSR after copying the reason to
                  the retention SRAM.
                  '''
                isdigest: false
                iszer: false
                ismubi: false
                iskeymgr_creator: false
                iskeymgr_owner: false
                inv_default: 0
                offset: 980
              }
              {
                name: OWNER_SW_CFG_ROM_RESET_REASON_CHECK_VALUE
                size: 4
                desc:
                  '''
                  Two packed 16-bit values that indicate whether the ROM
                  should perform a validation check on the the reset reasons
                  during boot. The validation check is a hardening mechanism
                  that checks the reset reasons for consistency at two
                  different points in time. Both packed values should be the
                  same. Values of kHardenedBoolFalse will instruct the ROM to
                  skip the reset reasons validation check, while all other
                  values will instruct the ROM to perform the check.
                  '''
                isdigest: false
                iszer: false
                ismubi: false
                iskeymgr_creator: false
                iskeymgr_owner: false
                inv_default: 0
                offset: 984
              }
              {
                name: OWNER_SW_CFG_ROM_BANNER_EN
                size: 4
                desc:
                  '''
                  Whether or not the ROM should print a banner message to the
                  console UART during boot. A value of kHardenedBoolFalse
                  disables the message printing, while all other values enable
                  it.
                  '''
                isdigest: false
                iszer: false
                ismubi: false
                iskeymgr_creator: false
                iskeymgr_owner: false
                inv_default: 0
                offset: 988
              }
              {
                name: OWNER_SW_CFG_ROM_FLASH_ECC_EXC_HANDLER_EN
                size: 4
                desc:
                  '''
                  Whether or not the ROM should use the flash ECC exception
                  handler during execution. A value of kHardenedBoolTrue
                  allows the ROM to use an the exception handler that recovers
                  gracefully and continues the boot process if a flash ECC
                  error is encountered during verification of a specific
                  ROM_EXT slot. This enables the ROM to attempt booting the
                  next ROM_EXT slot if the first slot attempted has been
                  corrupted. All other values trigger default ROM exception
                  handling, which is all exceptions trigger a chip shutdown
                  and reset.
                  '''
                isdigest: false
                iszer: false
                ismubi: false
                iskeymgr_creator: false
                iskeymgr_owner: false
                inv_default: 0
                offset: 992
              }
              {
                name: OWNER_SW_CFG_RESERVED
                size: 128
                desc:
                  '''
                  Unused bits in the OWNER_SW_CFG OTP partition. These can be
                  claimed by software as needed.
                  '''
                isdigest: false
                iszer: false
                ismubi: false
                iskeymgr_creator: false
                iskeymgr_owner: false
                inv_default: 0
                offset: 996
              }
              {
                name: OWNER_SW_CFG_DIGEST
                size: 8
                offset: 1136
                ismubi: false
                isdigest: true
                iszer: false
                inv_default: 17516780477869362820
                iskeymgr_creator: false
                iskeymgr_owner: false
              }
            ]
            desc:
              '''
              Software configuration partition.
              This contains data that changes software behavior in the ROM, for
              example enabling defensive features in ROM or selecting failure
              modes if verification fails.
              '''
            iskeymgr_creator: false
            iskeymgr_owner: false
            zeroizable: false
            ignore_read_lock_in_rma: false
            size: 712
            offset: 432
          }
          {
            name: ROT_CREATOR_AUTH_CODESIGN
            variant: Unbuffered
            absorb: false
            secret: false
            sw_digest: true
            hw_digest: false
            write_lock: Digest
            read_lock: CSR
            key_sel: NoKey
            integrity: true
            bkout_type: false
            items:
            [
              {
                name: ROT_CREATOR_AUTH_CODESIGN_ECDSA_KEY_TYPE0
                size: 4
                isdigest: false
                iszer: false
                ismubi: false
                iskeymgr_creator: false
                iskeymgr_owner: false
                inv_default: 0
                offset: 1144
              }
              {
                name: ROT_CREATOR_AUTH_CODESIGN_ECDSA_KEY0
                size: 64
                isdigest: false
                iszer: false
                ismubi: false
                iskeymgr_creator: false
                iskeymgr_owner: false
                inv_default: 0
                offset: 1148
              }
              {
                name: ROT_CREATOR_AUTH_CODESIGN_ECDSA_KEY_TYPE1
                size: 4
                isdigest: false
                iszer: false
                ismubi: false
                iskeymgr_creator: false
                iskeymgr_owner: false
                inv_default: 0
                offset: 1212
              }
              {
                name: ROT_CREATOR_AUTH_CODESIGN_ECDSA_KEY1
                size: 64
                isdigest: false
                iszer: false
                ismubi: false
                iskeymgr_creator: false
                iskeymgr_owner: false
                inv_default: 0
                offset: 1216
              }
              {
                name: ROT_CREATOR_AUTH_CODESIGN_ECDSA_KEY_TYPE2
                size: 4
                isdigest: false
                iszer: false
                ismubi: false
                iskeymgr_creator: false
                iskeymgr_owner: false
                inv_default: 0
                offset: 1280
              }
              {
                name: ROT_CREATOR_AUTH_CODESIGN_ECDSA_KEY2
                size: 64
                isdigest: false
                iszer: false
                ismubi: false
                iskeymgr_creator: false
                iskeymgr_owner: false
                inv_default: 0
                offset: 1284
              }
              {
                name: ROT_CREATOR_AUTH_CODESIGN_ECDSA_KEY_TYPE3
                size: 4
                isdigest: false
                iszer: false
                ismubi: false
                iskeymgr_creator: false
                iskeymgr_owner: false
                inv_default: 0
                offset: 1348
              }
              {
                name: ROT_CREATOR_AUTH_CODESIGN_ECDSA_KEY3
                size: 64
                isdigest: false
                iszer: false
                ismubi: false
                iskeymgr_creator: false
                iskeymgr_owner: false
                inv_default: 0
                offset: 1352
              }
              {
                name: ROT_CREATOR_AUTH_CODESIGN_SPX_KEY_TYPE0
                size: 4
                isdigest: false
                iszer: false
                ismubi: false
                iskeymgr_creator: false
                iskeymgr_owner: false
                inv_default: 0
                offset: 1416
              }
              {
                name: ROT_CREATOR_AUTH_CODESIGN_SPX_KEY0
                size: 32
                isdigest: false
                iszer: false
                ismubi: false
                iskeymgr_creator: false
                iskeymgr_owner: false
                inv_default: 0
                offset: 1420
              }
              {
                name: ROT_CREATOR_AUTH_CODESIGN_SPX_KEY_CONFIG0
                size: 4
                isdigest: false
                iszer: false
                ismubi: false
                iskeymgr_creator: false
                iskeymgr_owner: false
                inv_default: 0
                offset: 1452
              }
              {
                name: ROT_CREATOR_AUTH_CODESIGN_SPX_KEY_TYPE1
                size: 4
                isdigest: false
                iszer: false
                ismubi: false
                iskeymgr_creator: false
                iskeymgr_owner: false
                inv_default: 0
                offset: 1456
              }
              {
                name: ROT_CREATOR_AUTH_CODESIGN_SPX_KEY1
                size: 32
                isdigest: false
                iszer: false
                ismubi: false
                iskeymgr_creator: false
                iskeymgr_owner: false
                inv_default: 0
                offset: 1460
              }
              {
                name: ROT_CREATOR_AUTH_CODESIGN_SPX_KEY_CONFIG1
                size: 4
                isdigest: false
                iszer: false
                ismubi: false
                iskeymgr_creator: false
                iskeymgr_owner: false
                inv_default: 0
                offset: 1492
              }
              {
                name: ROT_CREATOR_AUTH_CODESIGN_SPX_KEY_TYPE2
                size: 4
                isdigest: false
                iszer: false
                ismubi: false
                iskeymgr_creator: false
                iskeymgr_owner: false
                inv_default: 0
                offset: 1496
              }
              {
                name: ROT_CREATOR_AUTH_CODESIGN_SPX_KEY2
                size: 32
                isdigest: false
                iszer: false
                ismubi: false
                iskeymgr_creator: false
                iskeymgr_owner: false
                inv_default: 0
                offset: 1500
              }
              {
                name: ROT_CREATOR_AUTH_CODESIGN_SPX_KEY_CONFIG2
                size: 4
                isdigest: false
                iszer: false
                ismubi: false
                iskeymgr_creator: false
                iskeymgr_owner: false
                inv_default: 0
                offset: 1532
              }
              {
                name: ROT_CREATOR_AUTH_CODESIGN_SPX_KEY_TYPE3
                size: 4
                isdigest: false
                iszer: false
                ismubi: false
                iskeymgr_creator: false
                iskeymgr_owner: false
                inv_default: 0
                offset: 1536
              }
              {
                name: ROT_CREATOR_AUTH_CODESIGN_SPX_KEY3
                size: 32
                isdigest: false
                iszer: false
                ismubi: false
                iskeymgr_creator: false
                iskeymgr_owner: false
                inv_default: 0
                offset: 1540
              }
              {
                name: ROT_CREATOR_AUTH_CODESIGN_SPX_KEY_CONFIG3
                size: 4
                isdigest: false
                iszer: false
                ismubi: false
                iskeymgr_creator: false
                iskeymgr_owner: false
                inv_default: 0
                offset: 1572
              }
              {
                name: ROT_CREATOR_AUTH_CODESIGN_BLOCK_SHA2_256_HASH
                size: 32
                isdigest: false
                iszer: false
                ismubi: false
                iskeymgr_creator: false
                iskeymgr_owner: false
                inv_default: 0
                offset: 1576
              }
              {
                name: ROT_CREATOR_AUTH_CODESIGN_DIGEST
                size: 8
                offset: 1608
                ismubi: false
                isdigest: true
                iszer: false
                inv_default: 10004875136179899350
                iskeymgr_creator: false
                iskeymgr_owner: false
              }
            ]
            desc:
              '''
              This OTP partition is used to store four P-256 keys
              and four Sphincs+ keys. The partition requires 464
              bytes of software visible storage. The partition is
              locked at manufacturing time to protect against
              malicious write attempts.
              '''
            iskeymgr_creator: false
            iskeymgr_owner: false
            zeroizable: false
            ignore_read_lock_in_rma: false
            size: 472
            offset: 1144
          }
          {
            name: ROT_CREATOR_AUTH_STATE
            variant: Unbuffered
            absorb: false
            secret: false
            sw_digest: true
            hw_digest: false
            write_lock: Digest
            read_lock: CSR
            key_sel: NoKey
            integrity: true
            bkout_type: false
            items:
            [
              {
                name: ROT_CREATOR_AUTH_STATE_ECDSA_KEY0
                size: 4
                isdigest: false
                iszer: false
                ismubi: false
                iskeymgr_creator: false
                iskeymgr_owner: false
                inv_default: 0
                offset: 1616
              }
              {
                name: ROT_CREATOR_AUTH_STATE_ECDSA_KEY1
                size: 4
                isdigest: false
                iszer: false
                ismubi: false
                iskeymgr_creator: false
                iskeymgr_owner: false
                inv_default: 0
                offset: 1620
              }
              {
                name: ROT_CREATOR_AUTH_STATE_ECDSA_KEY2
                size: 4
                isdigest: false
                iszer: false
                ismubi: false
                iskeymgr_creator: false
                iskeymgr_owner: false
                inv_default: 0
                offset: 1624
              }
              {
                name: ROT_CREATOR_AUTH_STATE_ECDSA_KEY3
                size: 4
                isdigest: false
                iszer: false
                ismubi: false
                iskeymgr_creator: false
                iskeymgr_owner: false
                inv_default: 0
                offset: 1628
              }
              {
                name: ROT_CREATOR_AUTH_STATE_SPX_KEY0
                size: 4
                isdigest: false
                iszer: false
                ismubi: false
                iskeymgr_creator: false
                iskeymgr_owner: false
                inv_default: 0
                offset: 1632
              }
              {
                name: ROT_CREATOR_AUTH_STATE_SPX_KEY1
                size: 4
                isdigest: false
                iszer: false
                ismubi: false
                iskeymgr_creator: false
                iskeymgr_owner: false
                inv_default: 0
                offset: 1636
              }
              {
                name: ROT_CREATOR_AUTH_STATE_SPX_KEY2
                size: 4
                isdigest: false
                iszer: false
                ismubi: false
                iskeymgr_creator: false
                iskeymgr_owner: false
                inv_default: 0
                offset: 1640
              }
              {
                name: ROT_CREATOR_AUTH_STATE_SPX_KEY3
                size: 4
                isdigest: false
                iszer: false
                ismubi: false
                iskeymgr_creator: false
                iskeymgr_owner: false
                inv_default: 0
                offset: 1644
              }
              {
                name: ROT_CREATOR_AUTH_STATE_DIGEST
                size: 8
                offset: 1648
                ismubi: false
                isdigest: true
                iszer: false
                inv_default: 8230641386344453198
                iskeymgr_creator: false
                iskeymgr_owner: false
              }
            ]
            desc:
              '''
              This OTP partition is used to capture the state of
              each key slot. Each key can be in one of the
              following states: BLANK, ENABLED, DISABLED. The
              encoded values are such that transitions between
              BLANK -> ENABLED ->  DISABLED are possible without
              causing ECC errors (this is a mechanism similar to
              how we manage life cycle state transitions). The
              partition is left unlocked to allow STATE updates in
              the field. The ROM_EXT is required to lock access to
              the OTP Direct Access Interface to prevent DoS
              attacks from malicious code executing on Silicon
              Owner partitions. DAI write locking is available in
              EarlGrey.
              '''
            iskeymgr_creator: false
            iskeymgr_owner: false
            zeroizable: false
            ignore_read_lock_in_rma: false
            size: 40
            offset: 1616
          }
          {
            name: HW_CFG0
            variant: Buffered
            secret: false
            sw_digest: false
            hw_digest: true
            write_lock: Digest
            read_lock: None
            key_sel: NoKey
            integrity: true
            bkout_type: true
            skip_sw_header: true
            items:
            [
              {
                name: DEVICE_ID
                size: 32
                inv_default: 52802220864608503837711356647287192946536634693415900517553687803248798893103
                desc:
                  '''
                  Unique device identifier that is always exposed through the
                  lifecycle JTAG tap. See OpenTitan documentation on Device
                  Identifiers.
                  '''
                isdigest: false
                iszer: false
                ismubi: false
                iskeymgr_creator: false
                iskeymgr_owner: false
                offset: 1656
              }
              {
                name: MANUF_STATE
                size: 32
                inv_default: 44006333694227272956693949958715563173174492152061281456758559295070352469441
                desc:
                  '''
                  Field to capture manufacturing status. Currently unused. Set
                  to 0.
                  '''
                isdigest: false
                iszer: false
                ismubi: false
                iskeymgr_creator: false
                iskeymgr_owner: false
                offset: 1688
              }
              {
                name: HW_CFG0_DIGEST
                size: 8
                offset: 1720
                ismubi: false
                isdigest: true
                iszer: false
                inv_default: 4145059766904508966
                iskeymgr_creator: false
                iskeymgr_owner: false
              }
            ]
            desc:
              '''
              Hardware configuration 0 partition.
              This contains a device identifier and manufacturing state.
              '''
            absorb: false
            iskeymgr_creator: false
            iskeymgr_owner: false
            zeroizable: false
            ignore_read_lock_in_rma: false
            size: 72
            offset: 1656
          }
          {
            name: HW_CFG1
            variant: Buffered
            secret: false
            sw_digest: false
            hw_digest: true
            write_lock: Digest
            read_lock: None
            key_sel: NoKey
            integrity: true
            bkout_type: true
            skip_sw_header: true
            items:
            [
              {
                name: EN_SRAM_IFETCH
                size: 1
                ismubi: true
                inv_default: 105
                desc:
                  '''
                  Enablement of execute from SRAM switch in the sram_ctrl (see
                  EXEC CSR). A kMultiBitBool8True value enables, while all
                  other values disable.
                  '''
                isdigest: false
                iszer: false
                iskeymgr_creator: false
                iskeymgr_owner: false
                offset: 1728
              }
              {
                name: EN_CSRNG_SW_APP_READ
                size: 1
                ismubi: true
                inv_default: 105
                desc:
                  '''
                  Enablement of CSRNG software application interface. A
                  kMultiBitBool8True value enables, while all other values
                  disable. Enablement is required to extract output from
                  CSRNG via software.
                  '''
                isdigest: false
                iszer: false
                iskeymgr_creator: false
                iskeymgr_owner: false
                offset: 1729
              }
              {
                name: DIS_RV_DM_LATE_DEBUG
                size: 1
                ismubi: true
                inv_default: 105
                desc:
                  '''
                  Disablement of RV_DM late debug feature (see rv_dm
                  documentation). A kMultiBitBool8True disables the late debug
                  feature and renders the rv_dm fully ungated in DEV lifecycle
                  states. All other values gate rv_dm reachability based on
                  the value of LATE_DEBUG_ENABLE CSR in the rv_dm block.
                  '''
                isdigest: false
                iszer: false
                iskeymgr_creator: false
                iskeymgr_owner: false
                offset: 1730
              }
              {
                name: HW_CFG1_DIGEST
                size: 8
                offset: 1736
                ismubi: false
                isdigest: true
                iszer: false
                inv_default: 10448389044042765021
                iskeymgr_creator: false
                iskeymgr_owner: false
              }
            ]
            desc:
              '''
              Hardware configuration 1 partition.
              This contains several hardware feature switches.
              '''
            absorb: false
            iskeymgr_creator: false
            iskeymgr_owner: false
            zeroizable: false
            ignore_read_lock_in_rma: false
            size: 16
            offset: 1728
          }
          {
            name: SECRET0
            variant: Buffered
            secret: true
            sw_digest: false
            hw_digest: true
            write_lock: Digest
            read_lock: Digest
            ignore_read_lock_in_rma: true
            key_sel: Secret0Key
            integrity: true
            bkout_type: false
            skip_sw_header: true
            items:
            [
              {
                name: TEST_UNLOCK_TOKEN
                inv_default: 208186818845381378382258058636907018373
                size: 16
                isdigest: false
                iszer: false
                ismubi: false
                iskeymgr_creator: false
                iskeymgr_owner: false
                offset: 1744
              }
              {
                name: TEST_EXIT_TOKEN
                inv_default: 20677840707601421473471848780681763222
                size: 16
                isdigest: false
                iszer: false
                ismubi: false
                iskeymgr_creator: false
                iskeymgr_owner: false
                offset: 1760
              }
              {
                name: SECRET0_DIGEST
                size: 8
                offset: 1776
                ismubi: false
                isdigest: true
                iszer: false
                inv_default: 5539200504167244868
                iskeymgr_creator: false
                iskeymgr_owner: false
              }
            ]
            desc:
              '''
              Secret partition 0.
              This contains TEST lifecycle unlock tokens.
              '''
            absorb: false
            iskeymgr_creator: false
            iskeymgr_owner: false
            zeroizable: false
            size: 40
            offset: 1744
          }
          {
            name: SECRET1
            variant: Buffered
            secret: true
            sw_digest: false
            hw_digest: true
            write_lock: Digest
            read_lock: Digest
            ignore_read_lock_in_rma: true
            key_sel: Secret1Key
            integrity: true
            bkout_type: false
            skip_sw_header: true
            items:
            [
              {
                name: FLASH_ADDR_KEY_SEED
                inv_default: 45468928134275788991545873869688826503719511575753596833096165248745999241720
                size: 32
                isdigest: false
                iszer: false
                ismubi: false
                iskeymgr_creator: false
                iskeymgr_owner: false
                offset: 1784
              }
              {
                name: FLASH_DATA_KEY_SEED
                inv_default: 42067023397656232971303188458359095440464026953775379885125754893328795916837
                size: 32
                isdigest: false
                iszer: false
                ismubi: false
                iskeymgr_creator: false
                iskeymgr_owner: false
                offset: 1816
              }
              {
                name: SRAM_DATA_KEY_SEED
                inv_default: 319591236663997883296503332130008504071
                size: 16
                isdigest: false
                iszer: false
                ismubi: false
                iskeymgr_creator: false
                iskeymgr_owner: false
                offset: 1848
              }
              {
                name: SECRET1_DIGEST
                size: 8
                offset: 1864
                ismubi: false
                isdigest: true
                iszer: false
                inv_default: 8810494674505979319
                iskeymgr_creator: false
                iskeymgr_owner: false
              }
            ]
            desc:
              '''
              Secret partition 1.
              This contains SRAM and flash scrambling keys.
              '''
            absorb: false
            iskeymgr_creator: false
            iskeymgr_owner: false
            zeroizable: false
            size: 88
            offset: 1784
          }
          {
            name: SECRET2
            variant: Buffered
            secret: true
            sw_digest: false
            hw_digest: true
            write_lock: Digest
            read_lock: Digest
            ignore_read_lock_in_rma: true
            key_sel: Secret2Key
            integrity: true
            bkout_type: false
            skip_sw_header: true
            items:
            [
              {
                name: RMA_TOKEN
                inv_default: 43607467814989757028965575194142311026
                size: 16
                isdigest: false
                iszer: false
                ismubi: false
                iskeymgr_creator: false
                iskeymgr_owner: false
                offset: 1872
              }
              {
                name: CREATOR_ROOT_KEY_SHARE0
                inv_default: 89754299710908028823207978994280084582357363874455887336697590830984911246409
                size: 32
                iskeymgr_creator: true
                isdigest: false
                iszer: false
                ismubi: false
                iskeymgr_owner: false
                offset: 1888
              }
              {
                name: CREATOR_ROOT_KEY_SHARE1
                inv_default: 12874066877757179467650230033250684330563740985316953234135861337619123221457
                size: 32
                iskeymgr_creator: true
                isdigest: false
                iszer: false
                ismubi: false
                iskeymgr_owner: false
                offset: 1920
              }
              {
                name: SECRET2_DIGEST
                size: 8
                offset: 1952
                ismubi: false
                isdigest: true
                iszer: false
                inv_default: 3220005416749168533
                iskeymgr_creator: false
                iskeymgr_owner: false
              }
            ]
            desc:
              '''
              Secret partition 2.
              This contains RMA unlock token, creator root key, and creator seed.
              '''
            absorb: false
            iskeymgr_creator: true
            iskeymgr_owner: false
            zeroizable: false
            size: 88
            offset: 1872
          }
          {
            name: LIFE_CYCLE
            variant: LifeCycle
            secret: false
            sw_digest: false
            hw_digest: false
            write_lock: None
            read_lock: None
            key_sel: NoKey
            integrity: true
            bkout_type: false
            skip_sw_header: true
            items:
            [
              {
                name: LC_TRANSITION_CNT
                inv_default: 32484060511911149636544393835225833781216059498095584554216928416534517374538477359017884198433181064965811067913132
                size: 48
                isdigest: false
                iszer: false
                ismubi: false
                iskeymgr_creator: false
                iskeymgr_owner: false
                offset: 1960
              }
              {
                name: LC_STATE
                inv_default: 437667205087615333188085628045866432397523039409444830296954128064190536456691943009486807979545
                size: 40
                isdigest: false
                iszer: false
                ismubi: false
                iskeymgr_creator: false
                iskeymgr_owner: false
                offset: 2008
              }
            ]
            desc:
              '''
              Lifecycle partition.
              This contains lifecycle transition count and state. This partition
              cannot be locked since the life cycle state needs to advance to RMA
              in-field. Note that while this partition is not marked secret, it
              is not readable nor writeable via the DAI. Only the LC controller
              can access this partition, and even via the LC controller it is not
              possible to read the raw manufacturing life cycle state in encoded
              form, since that encoding is considered a netlist secret. The LC
              controller only exposes a decoded version of this state.
              '''
            absorb: false
            iskeymgr_creator: false
            iskeymgr_owner: false
            zeroizable: false
            ignore_read_lock_in_rma: false
            size: 88
            offset: 1960
          }
        ]
      }
    }
    {
      name: rom_ctrl
      type: rom_ctrl
      base_addrs:
      {
        rom:
        {
          hart: 0x00000000
        }
        regs:
        {
          hart: 0x40007000
        }
      }
      memory:
      {
        rom:
        {
          label: rom
          swaccess: ro
          data_intg_passthru: True
          exec: True
          byte_write: False
          size: 0x8000
        }
      }
      param_list:
      [
        {
          name: RndCnstScrNonce
          desc: Fixed nonce used for address / data scrambling
          type: bit [63:0]
          randcount: 64
          randtype: data
          name_top: RndCnstRomCtrlScrNonce
          default: 0x6cadd32fee5e02c9
          randwidth: 64
        }
        {
          name: RndCnstScrKey
          desc: Randomised constant used as a scrambling key for ROM data
          type: bit [127:0]
          randcount: 128
          randtype: data
          name_top: RndCnstRomCtrlScrKey
          default: 0x8cf9fab9e489a9dc71997c9549425fa4
          randwidth: 128
        }
      ]
    }
    {
      name: sram_ctrl
      type: sram_ctrl
      base_addrs:
      {
        regs:
        {
          hart: 0x40008000
        }
        ram:
        {
          hart: 0x10000000
        }
      }
      memory:
      {
        ram:
        {
          label: ram_main
          swaccess: rw
          data_intg_passthru: "true"
          exec: True
          byte_write: True
          size: 0x20000
        }
      }
      param_list:
      [
        {
          name: RndCnstSramKey
          desc: Compile-time random reset value for SRAM scrambling key.
          type: otp_ctrl_pkg::sram_key_t
          randcount: 128
          randtype: data
          name_top: RndCnstSramCtrlSramKey
          default: 0x51e01cefa2d7231cfa71fb8fe6ed90f0
          randwidth: 128
        }
        {
          name: RndCnstSramNonce
          desc: Compile-time random reset value for SRAM scrambling nonce.
          type: otp_ctrl_pkg::sram_nonce_t
          randcount: 128
          randtype: data
          name_top: RndCnstSramCtrlSramNonce
          default: 0xe96664f5275c94312765a573a32478e4
          randwidth: 128
        }
        {
          name: RndCnstLfsrSeed
          desc: Compile-time random bits for initial LFSR seed
          type: sram_ctrl_pkg::lfsr_seed_t
          randcount: 64
          randtype: data
          name_top: RndCnstSramCtrlLfsrSeed
          default: 0x4923dc5f32223124
          randwidth: 64
        }
        {
          name: RndCnstLfsrPerm
          desc: Compile-time random permutation for LFSR output
          type: sram_ctrl_pkg::lfsr_perm_t
          randcount: 64
          randtype: perm
          name_top: RndCnstSramCtrlLfsrPerm
          default: 0x4cbf98c5bdaf535017eed0ec1e5e550ba7088455b7a4442368a799a0ef6b7fc48131183f8a6ccf246c8d9f8ab093476e
          randwidth: 384
        }
      ]
    }
    {
      name: flash_ctrl
      type: flash_ctrl
      base_addrs:
      {
        core:
        {
          hart: 0x40009000
        }
        prim:
        {
          hart: 0x4000A000
        }
        mem:
        {
          hart: 0x20000000
        }
      }
      memory:
      {
        mem:
        {
          label: eflash
          swaccess: ro
          data_intg_passthru: "true"
          exec: True
          byte_write: False
          config:
          {
            banks: 2
            pages_per_bank: 64
            program_resolution: 8
            pgm_resolution_bytes: 64
            bytes_per_page: 2048
            bytes_per_bank: 131072
            size: 0x40000
          }
          size: 0x40000
        }
      }
      param_list:
      [
        {
          name: RndCnstAddrKey
          desc: Compile-time random bits for default address key
          type: flash_ctrl_pkg::flash_key_t
          randcount: 128
          randtype: data
          name_top: RndCnstFlashCtrlAddrKey
          default: 0x708e7f462ee7f458c6632520edec854a
          randwidth: 128
        }
        {
          name: RndCnstDataKey
          desc: Compile-time random bits for default data key
          type: flash_ctrl_pkg::flash_key_t
          randcount: 128
          randtype: data
          name_top: RndCnstFlashCtrlDataKey
          default: 0x5b47f12a006a33606c2b6386752ffef5
          randwidth: 128
        }
        {
          name: RndCnstAllSeeds
          desc: Compile-time random bits for default seeds
          type: flash_ctrl_top_specific_pkg::all_seeds_t
          randcount: 512
          randtype: data
          name_top: RndCnstFlashCtrlAllSeeds
          default: 0x144ccad68238fb816a7e7ffa053c02c860d56f6fc3670a89f95fe8059cac442fa56cbc6cd5c3d67d2fbf291abd6b3dc85df8baa13fce54f3652c11ebb9310847
          randwidth: 512
        }
        {
          name: RndCnstLfsrSeed
          desc: Compile-time random bits for initial LFSR seed
          type: flash_ctrl_top_specific_pkg::lfsr_seed_t
          randcount: 32
          randtype: data
          name_top: RndCnstFlashCtrlLfsrSeed
          default: 0x61323bc9
          randwidth: 32
        }
        {
          name: RndCnstLfsrPerm
          desc: Compile-time random permutation for LFSR output
          type: flash_ctrl_top_specific_pkg::lfsr_perm_t
          randcount: 32
          randtype: perm
          name_top: RndCnstFlashCtrlLfsrPerm
          default: 0x57d3df46c74af9e23ea5948da1cd8805368e84f
          randwidth: 160
        }
      ]
      template_type: flash_ctrl
    }
    {
      name: rv_core_ibex
      type: rv_core_ibex
      base_addrs:
      {
        cfg:
        {
          hart: 0x4000B000
        }
      }
      memory: {}
      param_list:
      [
        {
          name: RndCnstLfsrSeed
          desc: Default seed of the PRNG used for random instructions.
          type: ibex_pkg::lfsr_seed_t
          randcount: 32
          randtype: data
          name_top: RndCnstRvCoreIbexLfsrSeed
          default: 0x91d177e9
          randwidth: 32
        }
        {
          name: RndCnstLfsrPerm
          desc: Permutation applied to the LFSR of the PRNG used for random instructions.
          type: ibex_pkg::lfsr_perm_t
          randcount: 32
          randtype: perm
          name_top: RndCnstRvCoreIbexLfsrPerm
          default: 0x73c362717b823cafeab361c0628da2bc93da4719
          randwidth: 160
        }
        {
          name: RndCnstIbexKeyDefault
          desc: Default icache scrambling key
          type: logic [ibex_pkg::SCRAMBLE_KEY_W-1:0]
          randcount: 128
          randtype: data
          name_top: RndCnstRvCoreIbexIbexKeyDefault
          default: 0xd1507232827dd2ebbde1cd4a2b643bce
          randwidth: 128
        }
        {
          name: RndCnstIbexNonceDefault
          desc: Default icache scrambling nonce
          type: logic [ibex_pkg::SCRAMBLE_NONCE_W-1:0]
          randcount: 64
          randtype: data
          name_top: RndCnstRvCoreIbexIbexNonceDefault
          default: 0x944fa4ddf315ddec
          randwidth: 64
        }
      ]
      template_type: rv_core_ibex
    }
  ]
}
