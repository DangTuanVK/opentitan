// Copyright SafeRoot contributors.
// Licensed under the Apache License, Version 2.0, see LICENSE for details.
// SPDX-License-Identifier: Apache-2.0
//
// TOP SafeRoot configuration
// SafeRoot is a stripped-down Root of Trust derived from OpenTitan Earl Grey.
// It keeps 17 core IP blocks focused on crypto, security, and minimal I/O.
// Removed: uart1-3, i2c1-2, spi_host0/1, usbdev, pattgen, pwm_aon,
//          sysrst_ctrl_aon, adc_ctrl_aon, edn1, sram_ctrl_ret_aon, rv_dm, ast.
{ name: "saferoot",
  type: "top",

  // 32-bit datawidth
  datawidth: "32",

  // Power information for the design
  power: {
    domains: ["Aon", "0"],
    default: "0"
    wait_for_external_reset: false
  },

  // No unmanaged external clocks
  unmanaged_clocks: []

  // ===== CLOCK CONFIGURATION =================================================
  // SafeRoot removes USB clock (no USB peripheral).
  // Keeps: main (100 MHz), io (96 MHz), aon (200 kHz), io_div2, io_div4.
  clocks: {

    hier_paths: {
      top: "clkmgr_aon_clocks.", // top level is a struct
      ext: "",                   // ext is a port of the clock name
      lpg: "clkmgr_aon_cg_en.",  // top level struct for alert lpg reset enables
    },

    // Clock sources — no USB clock for SafeRoot
    srcs: [
      { name: "main", aon: "no",  freq: "50000000" },
      { name: "io",   aon: "no",  freq: "50000000" },
      // SafeRoot: USB clock removed — no USB peripheral
      { name: "aon",  aon: "yes", freq: "200000", ref: true}
    ],

    // Derived clock sources from io
    derived_srcs: [
      { name: "io_div2", aon: "no", div: 2, src: "io", freq: "25000000" },
      { name: "io_div4", aon: "no", div: 4, src: "io", freq: "12500000" }
    ],

    // Clock groups
    groups: [
      { name: "ast",     src:"ext", sw_cg: "no"                   },
      { name: "powerup", src:"top", sw_cg: "no"                   },
      { name: "trans",   src:"top", sw_cg: "hint", unique: "yes", },
      { name: "infra",   src:"top", sw_cg: "no",                  },
      { name: "secure",  src:"top", sw_cg: "no"                   },
      { name: "peri",    src:"top", sw_cg: "yes",  unique: "no"   },
      { name: "timers",  src:"top", sw_cg: "no"                   }
    ],
  },

  // ===== RESET CONFIGURATION =================================================
  // SafeRoot removes USB-related resets, i2c1/i2c2, spi_host0/spi_host1 resets.
  resets: {

    hier_paths: {
      top: "rstmgr_aon_resets.", // top level is a struct
      ext: "",                   // ext is a port of the clock name
      lpg: "rstmgr_aon_rst_en.", // top level struct for alert lpg reset enables
    },

    nodes: [
      { name: "por_aon",        gen: false, type: "top",                    clock: "aon"     },
      { name: "lc_src",         gen: false, type: "int",                    clock: "io_div4" },
      { name: "sys_src",        gen: false, type: "int",                    clock: "io_div4" },
      { name: "por",            gen: true,  type: "top", parent: "por_aon", clock: "main"    },
      { name: "por_io",         gen: true,  type: "top", parent: "por_aon", clock: "io"      },
      { name: "por_io_div2",    gen: true , type: "top", parent: "por_aon", clock: "io_div2" },
      { name: "por_io_div4",    gen: true , type: "top", parent: "por_aon", clock: "io_div4" },
      // SafeRoot: por_usb removed — no USB
      { name: "lc",             gen: true,  type: "top", parent: "lc_src",  clock: "main"    },
      { name: "lc_aon",         gen: true,  type: "top", parent: "lc_src",  clock: "aon"     },
      { name: "lc_io",          gen: true,  type: "top", parent: "lc_src",  clock: "io"      },
      { name: "lc_io_div2",     gen: true,  type: "top", parent: "lc_src",  clock: "io_div2" },
      { name: "lc_io_div4",     gen: true,  type: "top", parent: "lc_src",  clock: "io_div4" },
      // SafeRoot: lc_usb removed — no USB
      { name: "sys",            gen: true,  type: "top", parent: "sys_src", clock: "main"    },
      { name: "sys_io_div4",    gen: true,  type: "top", parent: "sys_src", clock: "io_div4" },
      { name: "spi_device",     gen: true,  type: "top", parent: "lc_src", clock: "io_div4", sw: true },
      // SafeRoot: spi_host0/1 removed — slave-only design (SPI-master gỡ khỏi QFN-32)
      // SafeRoot: usb, usb_aon resets removed — no USB
      { name: "i2c0",           gen: true,  type: "top", parent: "lc_src", clock: "io_div4", sw: true },
      // SafeRoot: i2c1, i2c2 resets removed — only 1 I2C
    ]
  },

  // ===== RESET REQUESTS ======================================================
  // SafeRoot: No debug module (rv_dm), so no Ndm reset request.
  reset_requests: {
    int: [
      {
        "name": "MainPwr",
        "desc": "main power glitch reset request",
        "module": "pwrmgr_aon"
      },
      {
        "name": "Esc",
        "desc": "escalation reset request",
        "module": "alert_handler"
      }
    ],
    // SafeRoot: debug reset requests removed — no rv_dm
    debug: [],
  },

  // Number of cores: used in rv_plic and timer
  num_cores: "1",

  // Any module with interrupts that doesn't specify plic
  // will have its interrupts sent here
  default_plic: "rv_plic"

  // Any module with alerts that doesn't specify alert_handler
  // will have its alerts sent here
  default_alert_handler: "alert_handler"

  // ===== ADDRESS SPACES ======================================================
  // SafeRoot uses a single "hart" address space (no DM sharing needed).
  addr_spaces: [
    { name: "hart",
      desc: "The main address space for the Ibex CPU"
      subspaces: [
        { name: "mmio",
          desc: '''
                MMIO region for SafeRoot. Excludes ROM, SRAM, and flash data memory.
                '''
          nodes: [
            // Peripheral MMIO (0x40200000)
            "spi_device",
            "gpio",
            "i2c0",
            "uart0",
            // System MMIO (0x40300000)
            "rv_timer",
            "rv_plic",
            "aon_timer_aon",
            "pwrmgr_aon",
            "clkmgr_aon",
            "rstmgr_aon",
            "pinmux_aon",
            // Security MMIO (0x40100000)
            "otp_ctrl.core",
            "otp_macro.prim",
            "lc_ctrl.regs",
            "alert_handler",
            "sensor_ctrl",
            "keymgr",
            // Crypto MMIO (0x40000000)
            "aes",
            "hmac",
            "kmac",
            "csrng",
            "entropy_src",
            "edn0",
            "otbn",
            // Memory controller regs
            "flash_ctrl.core",
            "flash_ctrl.prim",
            "sram_ctrl.regs",
            "rom_ctrl.regs",
            "rv_core_ibex",
          ]
        }
      ]
    },
  ]

  // ===== MODULE DEFINITIONS ==================================================
  // SafeRoot keeps 17 IP blocks + supporting infrastructure.
  // Address map follows SafeRoot SoC architecture:
  //   ROM:             0x00000000
  //   SRAM:            0x10000000
  //   Flash:           0x20000000
  //   Crypto MMIO:     0x40000000 - 0x40003FFF
  //   Security MMIO:   0x40100000 - 0x40104FFF
  //   Peripheral MMIO: 0x40200000 - 0x40203FFF
  //   System MMIO:     0x40300000 - 0x40306FFF
  module: [

    // =========================================================================
    // Crypto MMIO region: 0x40000000 - 0x40003FFF
    // =========================================================================

    { name: "aes",
      type: "aes",
      clock_srcs: {clk_i: "main", clk_edn_i: "main"},
      clock_group: "trans",
      reset_connections: {rst_ni: "lc", rst_edn_ni: "lc"},
      param_decl: {
        AESGCMEnable: "0",
        SecMasking: "1",
        SecSBoxImpl: "aes_pkg::SBoxImplDom"
      }
      base_addr: {
        hart: "0x40000000",
      },
    },
    { name: "hmac",
      type: "hmac",
      clock_srcs: {clk_i: "main"},
      clock_group: "trans",
      reset_connections: {rst_ni: "lc"},
      base_addr: {
        hart: "0x40010000",
      },
    },
    { name: "kmac",
      type: "kmac",
      param_decl: {
        EnMasking: "1",
      }
      clock_srcs: {clk_i: "main", clk_edn_i: "main"}
      clock_group: "trans"
      reset_connections: {rst_ni: "lc", rst_edn_ni: "lc"}
      base_addr: {
        hart: "0x40020000",
      }
    },
    { name: "csrng",
      type: "csrng",
      clock_srcs: {clk_i: "main"},
      clock_group: "secure",
      reset_connections: {rst_ni: "lc"},
      base_addr: {
        hart: "0x40030000",
      },
    },
    { name: "entropy_src",
      type: "entropy_src",
      clock_srcs: {clk_i: "main"},
      clock_group: "secure",
      reset_connections: {rst_ni: "lc"},
      base_addr: {
        hart: "0x40040000",
      },
    },
    { name: "edn0",
      type: "edn",
      // SafeRoot: single EDN instance (Earl Grey had edn0 + edn1)
      clock_srcs: {clk_i: "main"},
      clock_group: "secure",
      reset_connections: {rst_ni: "lc"},
      base_addr: {
        hart: "0x40005000",
      },
      param_decl: {
        // SafeRoot: fewer endpoints since we have fewer consumers.
        // 8 = keymgr, otp_ctrl, kmac, alert_handler, aes, otbn.edn_urnd,
        //     otbn.edn_rnd, rv_core_ibex  (edn.sv default/max NumEndPoints = 8).
        NumEndPoints: "8",
      },
    },
    // SafeRoot: OTBN kept but optional — can be removed for area-constrained variants
    { name: "otbn",
      type: "otbn",
      // OPTIONAL: OTBN provides hardware crypto acceleration (ECC, RSA).
      // For area-constrained SafeRoot variants, OTBN can be removed and
      // these operations performed in software on Ibex (slower but smaller).
      clock_srcs: {
        clk_i: {
          clock: "main",
          group: "trans"
        },
        clk_edn_i: {
          clock: "main",
          group: "secure"
        },
        clk_otp_i: {
          clock: "io_div4",
          group: "secure"
        },
      },
      clock_group: "trans",
      reset_connections: {rst_ni: "lc", rst_edn_ni: "lc", rst_otp_ni: "lc_io_div4"},
      base_addr: {
        hart: "0x40080000",
      },
    },

    // =========================================================================
    // Security MMIO region: 0x40100000 - 0x40104FFF
    // =========================================================================

    { name: "keymgr",
      type: "keymgr",
      clock_srcs: {clk_i: "main", clk_edn_i: "main"},
      clock_group: "secure",
      reset_connections: {rst_ni: "lc", rst_edn_ni: "lc"},
      base_addr: {
        hart: "0x40100000",
      },
    },
    { name: "lc_ctrl",
      type: "lc_ctrl",
      clock_srcs: {clk_i: "io_div4", clk_kmac_i: "main"},
      clock_group: "secure",
      reset_connections: {rst_ni: "lc_io_div4", rst_kmac_ni: "lc"},
      base_addrs: {
        regs: {hart: "0x40101000"},
        dmi:  {hart: "0x0"}, // DMI is not used in SafeRoot
      },
      param_decl: {
        SecVolatileRawUnlockEn: "top_pkg::SecVolatileRawUnlockEn",
        SiliconCreatorId: "16'h 4002", // Creator ID for SafeRoot
        ProductId: "16'h 0001",        // SafeRoot product
        RevisionId: "8'h 01",          // First revision
        IdcodeValue: "jtag_id_pkg::LC_CTRL_JTAG_IDCODE",
        EscNumSeverities: "AlertHandlerEscNumSeverities",
        EscPingCountWidth: "AlertHandlerEscPingCountWidth",
      },
    },
    { name: "alert_handler",
      type: "alert_handler",
      template_type: "alert_handler",
      clock_srcs: {clk_i: "io_div4", clk_edn_i: "main"},
      clock_group: "secure",
      reset_connections: {rst_ni: "lc_io_div4", rst_edn_ni: "lc"},
      base_addr: {
        hart: "0x40120000",
      },
      param_decl: {
        EscNumSeverities: "4",
        EscPingCountWidth: "16"
      },
      attr: "ipgen",
    },
    { name: "otp_ctrl",
      type: "otp_ctrl",
      template_type: "otp_ctrl",
      clock_srcs: {clk_i: "io_div4", clk_edn_i: "main"},
      clock_group: "secure",
      reset_connections: {rst_ni: "lc_io_div4", rst_edn_ni: "lc"},
      base_addrs: {
        core: {hart: "0x40130000"},
      }
      attr: "ipgen"
    },
    {
      name: "otp_macro",
      type: "otp_macro",
      clock_srcs: {clk_i: "io_div4"},
      clock_group: "secure",
      reset_connections: {rst_ni: "lc_io_div4"},
      base_addrs: {
        prim: {hart: "0x40138000"},
      },
      param_decl: {
        Width: "otp_ctrl_macro_pkg::OtpWidth",
        Depth: "otp_ctrl_macro_pkg::OtpDepth",
        SizeWidth: "otp_ctrl_macro_pkg::OtpSizeWidth",
        VendorTestOffset: "otp_ctrl_reg_pkg::VendorTestOffset",
        VendorTestSize: "otp_ctrl_reg_pkg::VendorTestSize",
      },
    },
    { name: "sensor_ctrl",
      // SafeRoot: renamed from sensor_ctrl_aon — SafeRoot uses simpler sensor_ctrl
      // without the full AST (analog sensor top). Provides tamper detection
      // and environmental monitoring directly.
      type: "sensor_ctrl",
      clock_srcs: {clk_i: "io_div4", clk_aon_i: "aon"},
      clock_group: "secure",
      reset_connections: {rst_ni: "lc_io_div4", rst_aon_ni: "lc_aon"},
      domain: ["Aon"],
      base_addr: {
        hart: "0x40140000",
      },
      attr: "reggen_top",
    },

    // =========================================================================
    // Peripheral MMIO region: 0x40200000 - 0x40203FFF
    // =========================================================================

    { name: "spi_device",
      // SafeRoot PRIMARY interface — SPI slave for host communication
      type: "spi_device",
      clock_srcs: {clk_i: "io_div4", scan_clk_i: "io_div2"},
      clock_group: "peri",
      reset_connections: {rst_ni: "spi_device"},
      base_addr: {
        hart: "0x40200000",
      },
    },
    { name: "gpio",
      type: "gpio",
      template_type: "gpio",
      clock_srcs: {clk_i: "io_div4"},
      clock_group: "peri",
      reset_connections: {rst_ni: "lc_io_div4"},
      base_addr: {
        hart: "0x40210000",
      },
      param_decl: {
        GpioAsHwStrapsEn: "0",
        GpioAsyncOn: "1"
      },
      attr: "ipgen"
    },
    { name: "i2c0",
      // SafeRoot: single I2C instance (optional, for side-band management)
      type: "i2c",
      clock_srcs: {clk_i: "io_div4"},
      clock_group: "peri",
      reset_connections: {rst_ni: "i2c0"},
      base_addr: {
        hart: "0x40220000",
      },
    },
    { name: "uart0",
      // SafeRoot: single UART for debug console only
      type: "uart",
      clock_srcs: {clk_i: "io_div4"},
      clock_group: "peri",
      reset_connections: {rst_ni: "lc_io_div4"},
      base_addr: {
        hart: "0x40230000",
      },
    },

    // =========================================================================
    // System MMIO region: 0x40300000 - 0x40306FFF
    // =========================================================================

    { name: "rv_plic",
      type: "rv_plic",
      template_type: "rv_plic",
      clock_srcs: {clk_i: "main"},
      clock_group: "secure",
      reset_connections: {rst_ni: "lc"},
      base_addr: {
        hart: "0x48000000",
      },
      attr: "ipgen",
      targets: ["rv_core_ibex"]
    },
    { name: "rv_timer",
      type: "rv_timer",
      clock_srcs: {clk_i: "io_div4"},
      clock_group: "timers",
      reset_connections: {rst_ni: "lc_io_div4"},
      base_addr: {
        hart: "0x40310000",
      },
    },
    { name: "aon_timer_aon",
      type: "aon_timer",
      clock_srcs: {clk_i: "io_div4", clk_aon_i: "aon"},
      clock_group: "timers",
      reset_connections: {rst_ni: "lc_io_div4", rst_aon_ni: "lc_aon"},
      domain: ["Aon"],
      base_addr: {
        hart: "0x40320000",
      },
    },
    { name: "pwrmgr_aon",
      type: "pwrmgr",
      template_type: "pwrmgr",
      clock_group: "powerup",
      clock_srcs: {
        clk_i: "io_div4",
        clk_slow_i: "aon",
        clk_lc_i: "io_div4",
        clk_esc_i: {
          clock: "io_div4",
          group: "secure"
        }
      },
      reset_connections: {
        rst_ni: {
          name: "por_io_div4",
          domain: "Aon"
        },
        rst_main_ni: {
          name: "por_aon",
          domain: "0"
        },
        rst_lc_ni: {
          name: "lc_io_div4",
          domain: "Aon"
        },
        rst_esc_ni: {
          name: "lc_io_div4",
          domain: "Aon"
        },
        rst_slow_ni: {
          name: "por_aon",
          domain: "Aon",
        },
      },
      domain: ["Aon", "0"],
      base_addr: {
        hart: "0x40330000",
      },
      param_decl: {
        EscNumSeverities: "AlertHandlerEscNumSeverities",
        EscPingCountWidth: "AlertHandlerEscPingCountWidth",
      },
      attr: "ipgen",
    },
    { name: "clkmgr_aon",
      type: "clkmgr",
      template_type: "clkmgr",
      clock_srcs: {
        clk_i: "io_div4",
        clk_main_i: {
          group: "ast",
          clock: "main"
        },
        clk_io_i: {
          group: "ast",
          clock: "io"
        },
        // SafeRoot: clk_usb_i removed — no USB
        clk_aon_i: {
          group: "ast",
          clock: "aon"
        }
      },
      clock_group: "powerup",
      reset_connections: {rst_ni: "lc_io_div4",
                          rst_aon_ni: "lc_aon",
                          rst_io_ni: "lc_io",
                          rst_io_div2_ni: "lc_io_div2",
                          rst_io_div4_ni: "lc_io_div4",
                          rst_main_ni: "lc",
                          // SafeRoot: rst_usb_ni removed — no USB
                          rst_root_ni: "por_io_div4",
                          rst_root_io_ni: "por_io",
                          rst_root_io_div2_ni: "por_io_div2",
                          rst_root_io_div4_ni: "por_io_div4",
                          rst_root_main_ni: "por",
                          // SafeRoot: rst_root_usb_ni removed — no USB
                         },
      domain: ["Aon"],
      base_addr: {
        hart: "0x40340000",
      },
      attr: "ipgen",
    },
    { name: "rstmgr_aon",
      type: "rstmgr",
      template_type: "rstmgr",
      clock_srcs: {
        clk_i: {
          clock: "io_div4",
          group: "powerup"
        },
        clk_por_i: "io_div4", clk_aon_i: "aon", clk_main_i: "main", clk_io_i: "io",
        // SafeRoot: clk_usb_i removed — no USB
        clk_io_div2_i: "io_div2", clk_io_div4_i: "io_div4"
      },
      clock_group: "powerup",
      reset_connections: {
        rst_ni: {
          name: "lc_io_div4",
          domain: "Aon"
        },
        rst_por_ni: {
          name: "por_io_div4",
          domain: "Aon"
        },
      },
      domain: ["Aon", "0"],
      base_addr: {
        hart: "0x40350000",
      },
      attr: "ipgen",
    },
    { name: "pinmux_aon",
      type: "pinmux",
      template_type: "pinmux",
      clock_srcs: {clk_i: "io_div4", clk_aon_i: "aon"},
      clock_group: "powerup",
      reset_connections: {rst_ni: "lc_io_div4",
                          rst_aon_ni: "lc_aon",
                          rst_sys_ni: "sys_io_div4"
                         },
      domain: ["Aon"],
      base_addr: {
        hart: "0x40360000",
      },
      attr: "ipgen",
      param_decl: {
        SecVolatileRawUnlockEn: "top_pkg::SecVolatileRawUnlockEn",
      }
    },

    // =========================================================================
    // Memory controllers (addresses outside MMIO regions)
    // =========================================================================

    { name: "rom_ctrl",
      type: "rom_ctrl",
      clock_srcs: {clk_i: "main"},
      clock_group: "infra",
      reset_connections: {rst_ni: "lc"},
      // SafeRoot ROM at 0x00000000
      base_addrs: {
        rom:  {hart: "0x00000000"},
        regs: {hart: "0x40007000"}
      }
      memory: {
        rom: {
          label:              "rom",
          swaccess:           "ro",
          data_intg_passthru: "true",
          exec:               "True",
          byte_write:         "False",
          size:               "0x8000",
          data_intg_passthru: "True"
        }
      },
      param_decl: {
        SecDisableScrambling: "1'b0"
      }
    },
    { name: "sram_ctrl",
      // SafeRoot: renamed from sram_ctrl_main — single SRAM controller
      // (no retention SRAM in SafeRoot; AON timer handles low-power state)
      type: "sram_ctrl",
      clock_srcs: {clk_i: "main", clk_otp_i: "io_div4"},
      clock_group: "infra",
      reset_connections: {rst_ni: "lc", rst_otp_ni: "lc_io_div4"},
      param_decl: {
        InstrExec: "1",
        NumPrinceRoundsHalf: "2",
        InstSize: "131072",
      },
      // SafeRoot SRAM at 0x10000000
      base_addrs: {
        regs: {hart: "0x40008000"},
        ram:  {hart: "0x10000000"}
      },
      memory: {
        ram: {
          label:      "ram_main",
          swaccess:   "rw",
          data_intg_passthru: "true",
          exec:       "True",
          byte_write: "True",
          size:       "0x20000"
        }
      }
    },
    { name: "flash_ctrl",
      type: "flash_ctrl",
      template_type: "flash_ctrl",
      clock_srcs: {clk_i: "main", clk_otp_i: "io_div4"},
      clock_group: "infra",
      reset_connections: {rst_ni: "lc", rst_otp_ni: "lc_io_div4"},
      // SafeRoot flash data at 0x20000000, controller regs in MMIO
      base_addrs: {
        core: {hart: "0x40009000"},
        prim: {hart: "0x4000A000"},
        mem:  {hart: "0x20000000"}
      }
      param_decl: {
        ProgFifoDepth: "4",
      },
      memory: {
        mem: {
          label:      "eflash",
          swaccess:   "ro",
          data_intg_passthru: "true",
          exec:       "True",
          byte_write: "False",
          config: {
            type: "flash",
            banks: 2,
            pages_per_bank: 256,
            program_resolution: 8,
          }
        }
      },
      attr: "ipgen",
    },

    // =========================================================================
    // CPU core
    // =========================================================================

    { name: "rv_core_ibex",
      type: "rv_core_ibex",
      template_type: "rv_core_ibex",
      attr: "ipgen",
      ipgen_params: {
        num_regions: 2
      }
      param_decl: {PMPEnable: "1",
                   PMPGranularity: "0",
                   PMPNumRegions: "16",
                   MHPMCounterNum: "2",
                   MHPMCounterWidth: "32",
                   PMPRstCfg: "ibex_pmp_reset_pkg::PmpCfgRst",
                   PMPRstAddr: "ibex_pmp_reset_pkg::PmpAddrRst",
                   PMPRstMsecCfg: "ibex_pmp_reset_pkg::PmpMseccfgRst",
                   RV32E: "0",
                   RV32M: "ibex_pkg::RV32MSingleCycle",
                   RV32B: "ibex_pkg::RV32BOTEarlGrey",
                   RV32ZC: "ibex_pkg::RV32ZcaZcbZcmp",
                   RegFile: "ibex_pkg::RegFileFF",
                   BranchTargetALU: "1",
                   WritebackStage: "1",
                   ICache: "1",
                   ICacheECC: "1",
                   ICacheScramble: "1",
                   BranchPredictor: "0",
                   DbgTriggerEn: "1",
                   DbgHwBreakNum: "4",
                   SecureIbex: "1",
                   // SafeRoot: no rv_dm, so DM addresses point to zero
                   DmBaseAddr: "32'h0",
                   DmAddrMask: "32'h0",
                   DmHaltAddr: "32'h0",
                   DmExceptionAddr: "32'h0",
                   PipeLine: "0",
                   NEscalationSeverities: "AlertHandlerEscNumSeverities",
                   WidthPingCounter: "AlertHandlerEscPingCountWidth",
                  },
      clock_srcs: {
        clk_i: "main",
        clk_edn_i: "main",
        clk_esc_i: {
          clock: "io_div4",
          group: "secure",
        },
        clk_otp_i: {
          clock: "io_div4",
          group: "secure",
        }
      },
      clock_group: "infra",
      reset_connections: {rst_ni: "lc",
                          rst_edn_ni: "lc",
                          rst_esc_ni: "lc_io_div4",
                          rst_otp_ni: "lc_io_div4"},
      base_addr: {
        hart: "0x4000B000",
      },
    },
  ],

  // ===== PORT DEFINITIONS ====================================================
  // SafeRoot: simplified ports — no AST port (SafeRoot uses sensor_ctrl directly)
  port: [
    { name: "ext_clk",
      inter_signal_list: [
        { struct:  "ram_1p_cfg",
          package: "prim_ram_1p_pkg",
          type:    "uni",
          name:    "ram_1p_cfg",
          act:     "rcv"
        },
        { struct:  "ram_2p_cfg",
          package: "prim_ram_2p_pkg",
          type:    "uni",
          name:    "spi_ram_2p_cfg",
          act:     "rcv"
        },
        { struct:  "rom_cfg",
          package: "prim_rom_pkg",
          type:    "uni",
          name:    "rom_cfg",
          act:     "rcv"
        },
      ]
    },
  ],

  // ===== INTER-MODULE CONNECTIONS ============================================
  // SafeRoot: stripped down from Earl Grey — removed all USB, rv_dm, spi_host,
  // sram_ctrl_ret_aon, ast, and multi-instance peripheral connections.
  inter_module: {
    'connect': {
      // RAM/ROM configuration from external port
      'ext_clk.ram_1p_cfg'         : ['otbn.ram_cfg_imem',
                                      'otbn.ram_cfg_dmem',
                                      'i2c0.ram_cfg',
                                      'rv_core_ibex.ram_cfg_icache_tag',
                                      'rv_core_ibex.ram_cfg_icache_data'],
      'ext_clk.spi_ram_2p_cfg'     : ['spi_device.ram_cfg_sys2spi',
                                      'spi_device.ram_cfg_spi2sys'],
      'ext_clk.rom_cfg'            : ['rom_ctrl.rom_cfg'],

      // Alert handler connections
      'alert_handler.crashdump'    : ['rstmgr_aon.alert_dump'],
      'alert_handler.esc_rx'       : ['rv_core_ibex.esc_rx',
                                      'lc_ctrl.esc_scrap_state0_rx',
                                      'lc_ctrl.esc_scrap_state1_rx',
                                      'pwrmgr_aon.esc_rst_rx'],
      'alert_handler.esc_tx'       : ['rv_core_ibex.esc_tx',
                                      'lc_ctrl.esc_scrap_state0_tx',
                                      'lc_ctrl.esc_scrap_state1_tx',
                                      'pwrmgr_aon.esc_rst_tx'],

      // AON timer NMI
      'aon_timer_aon.nmi_wdog_timer_bark' : ['rv_core_ibex.nmi_wdog'],

      // CSRNG / entropy chain
      // SafeRoot: single EDN (edn0 only, no edn1)
      'csrng.csrng_cmd'            : ['edn0.csrng_cmd'],
      'csrng.entropy_src_hw_if'    : ['entropy_src.entropy_src_hw_if'],

      // Flash controller connections
      'flash_ctrl.keymgr'          : ['keymgr.flash'],
      'flash_ctrl.otp'             : ['otp_ctrl.flash_otp_key'],
      'flash_ctrl.rma_seed'        : ['lc_ctrl.lc_flash_rma_seed'],

      // OTP SRAM key distribution
      // SafeRoot: only sram_ctrl (no sram_ctrl_ret_aon)
      'otp_ctrl.sram_otp_key'      : ['sram_ctrl.sram_otp_key',
                                      'rv_core_ibex.icache_otp_key'],

      // Power manager connections
      'pwrmgr_aon.pwr_flash'       : ['flash_ctrl.pwrmgr'],
      'pwrmgr_aon.pwr_rst'         : ['rstmgr_aon.pwr'],
      'pwrmgr_aon.pwr_clk'         : ['clkmgr_aon.pwr'],
      'pwrmgr_aon.pwr_otp'         : ['otp_ctrl.pwr_otp'],
      'pwrmgr_aon.pwr_lc'          : ['lc_ctrl.pwr_lc'],
      'pwrmgr_aon.strap'           : ['pinmux_aon.strap_en'],
      'pwrmgr_aon.low_power'       : ['pinmux_aon.sleep_en',
                                      'aon_timer_aon.sleep_mode'],
      'pwrmgr_aon.fetch_en'        : ['rv_core_ibex.pwrmgr_cpu_en'],

      // ROM controller connections
      'rom_ctrl.pwrmgr_data'       : ['pwrmgr_aon.rom_ctrl'],
      'rom_ctrl.keymgr_data'       : ['keymgr.rom_digest'],

      // LC RMA req/ack interface
      'lc_ctrl.lc_flash_rma_req'   : ['flash_ctrl.rma_req', 'otbn.lc_rma_req'],
      'lc_ctrl.lc_flash_rma_ack'   : ['flash_ctrl.rma_ack', 'otbn.lc_rma_ack'],

      // EDN entropy distribution
      // SafeRoot: all consumers on single edn0
      // otbn.edn_rnd MUST be here: without it topgen emits `.edn_rnd_o()` dangling and
      // `.edn_rnd_i(EDN_RSP_DEFAULT)` (='0, never acks), so ANY OTBN program reading the
      // RND WSR (p256_generate_k -> p256_random_scalar) hangs the core forever. It was
      // dropped when Earl Grey's edn1 was removed. See docs/lab-journal 2026-07-17.
      'edn0.edn'                   : ['keymgr.edn', 'otp_ctrl.edn', 'kmac.entropy',
                                      'alert_handler.edn', 'aes.edn', 'otbn.edn_urnd',
                                      'otbn.edn_rnd', 'rv_core_ibex.edn'],

      // OTBN OTP scramble key
      'otp_ctrl.otbn_otp_key'      : ['otbn.otbn_otp_key'],

      // KeyMgr sideload & KDF
      'otp_ctrl.otp_keymgr_key'    : ['keymgr.otp_key'],
      'keymgr.aes_key'             : ['aes.keymgr_key'],
      'keymgr.kmac_key'            : ['kmac.keymgr_key'],
      'keymgr.otbn_key'            : ['otbn.keymgr_key'],

      // KMAC application interface
      'kmac.app'                   : ['keymgr.kmac_data',    // index 0
                                      'lc_ctrl.kmac_data',   // index 1
                                      'rom_ctrl.kmac_data'], // index 2
      'kmac.en_masking'            : ['keymgr.kmac_en_masking'],

      // Clock manager idle — auto-connected by topgen
      'clkmgr_aon.idle'            : [],

      // Pinmux JTAG signals
      // SafeRoot: LC JTAG only (no rv_dm JTAG)
      'pinmux_aon.lc_jtag'         : ['lc_ctrl.jtag'],

      // OTP <-> LC interface
      'otp_ctrl.otp_lc_data'       : ['lc_ctrl.otp_lc_data'],
      'lc_ctrl.lc_otp_program'     : ['otp_ctrl.lc_otp_program'],

      // PRIM_OTP LC interface
      'lc_ctrl.lc_otp_vendor_test' : ['otp_macro.test'],

      // LC diversification constant
      'lc_ctrl.lc_keymgr_div'      : ['keymgr.lc_keymgr_div'],

      // Strap enable override
      'lc_ctrl.strap_en_override'  : ['pinmux_aon.strap_en_override'],

      // LC function control signal broadcast
      // SafeRoot: no rv_dm, no ast, no sram_ctrl_ret_aon in broadcast lists
      'lc_ctrl.lc_dft_en'          : ['otp_macro.lc_dft_en',
                                      'pinmux_aon.lc_dft_en',
                                      'pwrmgr_aon.lc_dft_en'],
      'lc_ctrl.lc_nvm_debug_en'    : ['flash_ctrl.lc_nvm_debug_en'],
      'lc_ctrl.lc_hw_debug_clr'    : ['pinmux_aon.lc_hw_debug_clr'],
      'lc_ctrl.lc_hw_debug_en'     : ['sram_ctrl.lc_hw_debug_en',
                                      'pinmux_aon.lc_hw_debug_en',
                                      'csrng.lc_hw_debug_en',
                                      'clkmgr_aon.lc_hw_debug_en',
                                      'pwrmgr_aon.lc_hw_debug_en'],
      'lc_ctrl.lc_cpu_en'          : ['rv_core_ibex.lc_cpu_en'],
      'lc_ctrl.lc_keymgr_en'       : ['keymgr.lc_keymgr_en'],
      'lc_ctrl.lc_escalate_en'     : ['aes.lc_escalate_en',
                                      'kmac.lc_escalate_en',
                                      'otbn.lc_escalate_en',
                                      'otp_ctrl.lc_escalate_en',
                                      'sram_ctrl.lc_escalate_en',
                                      'aon_timer_aon.lc_escalate_en',
                                      'flash_ctrl.lc_escalate_en',
                                      'pinmux_aon.lc_escalate_en'],

      'lc_ctrl.lc_check_byp_en'    : ['otp_ctrl.lc_check_byp_en',
                                      'pinmux_aon.lc_check_byp_en'],
      'lc_ctrl.lc_clk_byp_req'     : ['clkmgr_aon.lc_clk_byp_req'],
      'lc_ctrl.lc_clk_byp_ack'     : ['clkmgr_aon.lc_clk_byp_ack'],

      // LC access control signal broadcast
      'lc_ctrl.lc_creator_seed_sw_rw_en' : ['otp_ctrl.lc_creator_seed_sw_rw_en',
                                             'flash_ctrl.lc_creator_seed_sw_rw_en'],
      'lc_ctrl.lc_owner_seed_sw_rw_en'   : ['flash_ctrl.lc_owner_seed_sw_rw_en'],
      'lc_ctrl.lc_iso_part_sw_rd_en'     : ['flash_ctrl.lc_iso_part_sw_rd_en'],
      'lc_ctrl.lc_iso_part_sw_wr_en'     : ['flash_ctrl.lc_iso_part_sw_wr_en'],
      'lc_ctrl.lc_seed_hw_rd_en'         : ['otp_ctrl.lc_seed_hw_rd_en',
                                             'flash_ctrl.lc_seed_hw_rd_en'],
      'lc_ctrl.lc_rma_state'             : ['otp_ctrl.lc_rma_state'],

      // OTP <-> OTP_MACRO connections
      'otp_ctrl.otp_macro'               : ['otp_macro.otp'],

      // rv_plic connections
      'rv_plic.msip'               : ['rv_core_ibex.irq_software'],
      'rv_plic.irq'                : ['rv_core_ibex.irq_external'],

      // SafeRoot: no rv_dm.debug_req — debug uses JTAG directly, locked in PROD

      // rv_core_ibex connections
      'rv_core_ibex.crash_dump'    : ['rstmgr_aon.cpu_dump'],
      'rv_core_ibex.pwrmgr'        : ['pwrmgr_aon.pwr_cpu'],

      // SafeRoot: no spi passthrough (no spi_host0)
      // SafeRoot: no rv_dm.ndmreset_req

      // Reset manager software reset request to pwrmgr
      'rstmgr_aon.sw_rst_req'      : ['pwrmgr_aon.sw_rst_req'],
    },

    // top-level net connections
    'top': [
        // top level net for clocks
        'clkmgr_aon.clocks',
        // top level clock gating indications for alert subsystem
        'clkmgr_aon.cg_en',
        // top level net for reset
        'rstmgr_aon.resets',
        // top level reset asserted indications for alert subsystem
        'rstmgr_aon.rst_en',
        // dedicated timer interrupt
        'rv_core_ibex.irq_timer',
        // hardwired connections
        'rv_core_ibex.hart_id', 'rv_core_ibex.boot_addr',
        // Pinmux JTAG signals for the tool-inserted DFT TAP
        'pinmux_aon.dft_jtag',
        // OTP HW_CFG* broadcast signals
        'otp_ctrl.otp_broadcast',
        'csrng.otp_en_csrng_sw_app_read',
        'lc_ctrl.otp_device_id',
        'lc_ctrl.otp_manuf_state',
        'keymgr.otp_device_id',
        'sram_ctrl.otp_en_sram_ifetch',
    ],

    // external port connections
    'external': {
        'ext_clk.ram_1p_cfg'                     : 'ram_1p_cfg',
        'sram_ctrl.cfg'                          : 'sram_ctrl_cfg'
        'ext_clk.spi_ram_2p_cfg'                 : 'spi_ram_2p_cfg',
        'ext_clk.rom_cfg'                        : 'rom_cfg',
        'clkmgr_aon.jitter_en'                   : 'clk_main_jitter_en',
        'clkmgr_aon.io_clk_byp_req'             : 'io_clk_byp_req',
        'clkmgr_aon.io_clk_byp_ack'             : 'io_clk_byp_ack',
        'clkmgr_aon.all_clk_byp_req'            : 'all_clk_byp_req',
        'clkmgr_aon.all_clk_byp_ack'            : 'all_clk_byp_ack',
        'clkmgr_aon.hi_speed_sel'               : 'hi_speed_sel',
        'clkmgr_aon.div_step_down_req'          : 'div_step_down_req',
        'clkmgr_aon.calib_rdy'                  : 'calib_rdy',
        'flash_ctrl.flash_bist_enable'           : 'flash_bist_enable',
        'flash_ctrl.flash_power_down_h'          : 'flash_power_down_h',
        'flash_ctrl.flash_power_ready_h'         : 'flash_power_ready_h',
        'flash_ctrl.flash_test_mode_a'           : 'flash_test_mode_a',
        'flash_ctrl.flash_test_voltage_h'        : 'flash_test_voltage_h',
        'flash_ctrl.fla_obs'                     : 'flash_obs',
        'entropy_src.entropy_src_rng_enable'     : 'es_rng_enable',
        'entropy_src.entropy_src_rng_valid'      : 'es_rng_valid',
        'entropy_src.entropy_src_rng_bits'       : 'es_rng_bit',
        'entropy_src.rng_fips'                   : 'es_rng_fips',
        'pinmux_aon.dft_strap_test'              : 'dft_strap_test',
        'pinmux_aon.dft_hold_tap_sel'            : 'dft_hold_tap_sel',
        'pwrmgr_aon.pwr_ast'                     : 'pwrmgr_ast',
        'otp_macro.pwr_seq'                      : '',
        'otp_macro.pwr_seq_h'                    : '',
        'otp_macro.ext_voltage_h'                : 'otp_ext_voltage_h',
        'otp_macro.otp_obs'                      : 'otp_obs',
        'rstmgr_aon.por_n'                       : 'por_n',
        'rv_core_ibex.fpga_info'                 : 'fpga_info',
        'sensor_ctrl.ast_alert'                  : 'sensor_ctrl_ast_alert',
        'sensor_ctrl.ast_status'                 : 'sensor_ctrl_ast_status',
        'sensor_ctrl.ast2pinmux'                 : 'ast2pinmux',
        'sensor_ctrl.ast_init_done'              : 'ast_init_done',
        'sensor_ctrl.manual_pad_attr'            : 'sensor_ctrl_manual_pad_attr',
        'spi_device.sck_monitor'                 : 'sck_monitor',
    },
  },

  // ===== CROSSBAR ============================================================
  // SafeRoot: single crossbar (no separate xbar_peri — simpler design)
  xbar: [
    { name: "main",
      clock_srcs: {clk_main_i: "main",
                   clk_fixed_i: "io_div4"},
      // SafeRoot: removed clk_usb_i, clk_spi_host0_i, clk_spi_host1_i
      clock_group: "infra",
      reset: "lc",
      reset_connections: {rst_main_ni: "lc",
                          rst_fixed_ni: "lc_io_div4"}
      // SafeRoot: removed rst_usb_ni, rst_spi_host0_ni, rst_spi_host1_ni
    },
  ],

  // ===== PINOUT ==============================================================
  // SafeRoot: minimal pin count — 8 MIO pads + 10 DIO pads
  // DIO: SPI device (4 data + clk + cs = 6) + JTAG (tck, tms, tdi, tdo, trst_n = 5)
  //      - Total DIO count adjusted to actual connections below
  pinout: {
    banks: ['VCC'],
    pads: [
      // Special manually connected pads
      { name: 'POR_N'           , type: 'InputStd',     bank: 'VCC', connection: 'manual', desc: 'System reset'},
      { name: 'OTP_EXT_VOLT'    , type: 'AnalogIn1',    bank: 'VCC', connection: 'manual', desc: 'OTP external voltage input'},
      // Dedicated SPI device pads (PRIMARY interface)
      { name: 'SPI_DEV_D0'      , type: 'BidirStd', bank: 'VCC', connection: 'direct', desc: 'SPI device data 0'},
      { name: 'SPI_DEV_D1'      , type: 'BidirStd', bank: 'VCC', connection: 'direct', desc: 'SPI device data 1'},
      { name: 'SPI_DEV_D2'      , type: 'BidirStd', bank: 'VCC', connection: 'direct', desc: 'SPI device data 2'},
      { name: 'SPI_DEV_D3'      , type: 'BidirStd', bank: 'VCC', connection: 'direct', desc: 'SPI device data 3'},
      { name: 'SPI_DEV_CLK'     , type: 'InputStd', bank: 'VCC', connection: 'direct', desc: 'SPI device clock'},
      { name: 'SPI_DEV_CS_L'    , type: 'InputStd', bank: 'VCC', connection: 'direct', desc: 'SPI device chip select'},
      // Dedicated BOOT_OK output
      { name: 'BOOT_OK'         , type: 'BidirStd', bank: 'VCC', connection: 'manual', desc: 'Boot OK status output'},
      // Muxed IO pads (8 pads for UART, I2C, GPIO, etc.)
      { name: 'MIO0'            , type: 'BidirStd', bank: 'VCC', connection: 'muxed' , desc: 'Muxed IO pad'},
      { name: 'MIO1'            , type: 'BidirStd', bank: 'VCC', connection: 'muxed' , desc: 'Muxed IO pad'},
      { name: 'MIO2'            , type: 'BidirStd', bank: 'VCC', connection: 'muxed' , desc: 'Muxed IO pad'},
      { name: 'MIO3'            , type: 'BidirStd', bank: 'VCC', connection: 'muxed' , desc: 'Muxed IO pad'},
      { name: 'MIO4'            , type: 'BidirOd' , bank: 'VCC', connection: 'muxed' , desc: 'Muxed IO pad'},
      { name: 'MIO5'            , type: 'BidirOd' , bank: 'VCC', connection: 'muxed' , desc: 'Muxed IO pad'},
      { name: 'MIO6'            , type: 'BidirStd', bank: 'VCC', connection: 'muxed' , desc: 'Muxed IO pad'},
      { name: 'MIO7'            , type: 'BidirStd', bank: 'VCC', connection: 'muxed' , desc: 'Muxed IO pad'},
      // Option B (2026-07-06, chủ nhiệm chốt): +MIO8-15 → 16 MIO + 6 DIO = 22 pad tín hiệu
      // đủ full QFN-32 (SPI4+GPIO4+I2C2+JTAG5+control5 BOOT_OK/RESET_N/ALERT_N/WAKE/FAILSAFE).
      { name: 'MIO8'            , type: 'BidirStd', bank: 'VCC', connection: 'muxed' , desc: 'Muxed IO pad'},
      { name: 'MIO9'            , type: 'BidirStd', bank: 'VCC', connection: 'muxed' , desc: 'Muxed IO pad'},
      { name: 'MIO10'           , type: 'BidirStd', bank: 'VCC', connection: 'muxed' , desc: 'Muxed IO pad'},
      { name: 'MIO11'           , type: 'BidirStd', bank: 'VCC', connection: 'muxed' , desc: 'Muxed IO pad'},
      { name: 'MIO12'           , type: 'BidirStd', bank: 'VCC', connection: 'muxed' , desc: 'Muxed IO pad'},
      { name: 'MIO13'           , type: 'BidirStd', bank: 'VCC', connection: 'muxed' , desc: 'Muxed IO pad'},
      { name: 'MIO14'           , type: 'BidirStd', bank: 'VCC', connection: 'muxed' , desc: 'Muxed IO pad'},
      { name: 'MIO15'           , type: 'BidirStd', bank: 'VCC', connection: 'muxed' , desc: 'Muxed IO pad'},
    ]
  },

  // ===== PINMUX ==============================================================
  pinmux: {
    signals: [
      // SPI Device — dedicated IOs (PRIMARY interface for SafeRoot)
      { instance: 'spi_device',      port: 'sck',            connection: 'direct', pad: 'SPI_DEV_CLK'  , desc: ''},
      { instance: 'spi_device',      port: 'csb',            connection: 'direct', pad: 'SPI_DEV_CS_L' , desc: ''},
      { instance: 'spi_device',      port: 'sd[0]',          connection: 'direct', pad: 'SPI_DEV_D0'   , desc: ''},
      { instance: 'spi_device',      port: 'sd[1]',          connection: 'direct', pad: 'SPI_DEV_D1'   , desc: ''},
      { instance: 'spi_device',      port: 'sd[2]',          connection: 'direct', pad: 'SPI_DEV_D2'   , desc: ''},
      { instance: 'spi_device',      port: 'sd[3]',          connection: 'direct', pad: 'SPI_DEV_D3'   , desc: ''},
      // Muxed IOs — UART, I2C, GPIO, sensor_ctrl, flash_ctrl, SPI TPM
      { instance: "gpio",            port: '',               connection: 'muxed' , pad: ''             , desc: ''},
      { instance: "uart0",           port: '',               connection: 'muxed' , pad: ''             , desc: ''},
      { instance: "i2c0",            port: '',               connection: 'muxed' , pad: ''             , desc: ''},
      { instance: "spi_device",      port: 'tpm_csb',        connection: 'muxed' , pad: ''             , desc: ''},
      { instance: "flash_ctrl",      port: '',               connection: 'muxed' , pad: ''             , desc: ''},
      { instance: "sensor_ctrl",     port: '',               connection: 'muxed' , pad: ''             , desc: ''},
      { instance: "otp_macro",       port: 'test[0]',        connection: 'muxed' , pad: ''             , desc: ''},
    ],

    num_wkup_detect: 4,
    wkup_cnt_width:  8,
    // SafeRoot: no USB wakeup
    enable_usb_wakeup: false
    enable_strap_sampling: true
  },

  // ===== IMPLEMENTATION TARGETS ==============================================
  targets: [
    { name: 'asic',
      pinout: {
        remove_ports: [],
        remove_pads: [],
        add_pads: [],
      },
      pinmux: {
        special_signals: [
          // Straps
          { name: 'tap0',   pad: 'MIO0', desc: 'TAP strap signal.'   },
          { name: 'tap1',   pad: 'MIO1', desc: 'TAP strap signal.'   },
          { name: 'dft0',   pad: 'MIO2', desc: 'DFT strap signal.'   },
          { name: 'dft1',   pad: 'MIO3', desc: 'DFT strap signal.'   },
          // JTAG
          { name: 'tck',    pad: 'MIO4', desc: 'JTAG tck signal.'    },
          { name: 'tms',    pad: 'MIO5', desc: 'JTAG tms signal.'    },
          { name: 'trst_n', pad: 'MIO6', desc: 'JTAG trst_n signal.' },
          { name: 'tdi',    pad: 'MIO7', desc: 'JTAG tdi signal.'    },
          { name: 'tdo',    pad: 'MIO0', desc: 'JTAG tdo signal.'    },
        ],
      }
    },
  ]
}
